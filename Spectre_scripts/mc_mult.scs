// Design: Sangamesh_SRAM/6T_MAC

// terminal command: spectre final_trans.scs +escchars +log ../psf/spectre.out -format psfxl -raw ../psf +lqtimeout 900 -maxw 5 -maxn 5 +fastdc +mt=64 -64 +lqt=1 +aps=liberal

simulator lang=spectre

global 0
include "/home/nano01/a/agrawa64/mosis_65nm/mosis_65nm/tsmcN65/../models/spectre/crn65gplus_2d5_lk_v1d0.scs" section=tt_bip
include "/home/nano01/a/agrawa64/mosis_65nm/mosis_65nm/tsmcN65/../models/spectre/crn65gplus_2d5_lk_v1d0.scs" section=tt_dio
include "/home/nano01/a/agrawa64/mosis_65nm/mosis_65nm/tsmcN65/../models/spectre/crn65gplus_2d5_lk_v1d0.scs" section=tt_dio_33
include "/home/nano01/a/agrawa64/mosis_65nm/mosis_65nm/tsmcN65/../models/spectre/crn65gplus_2d5_lk_v1d0.scs" section=tt_mim
include "/home/nano01/a/agrawa64/mosis_65nm/mosis_65nm/tsmcN65/../models/spectre/crn65gplus_2d5_lk_v1d0.scs" section=tt_dio_dnw
include "/home/nano01/a/agrawa64/mosis_65nm/mosis_65nm/tsmcN65/../models/spectre/crn65gplus_2d5_lk_v1d0.scs" section=tt_dio_18
include "/home/nano01/a/agrawa64/mosis_65nm/mosis_65nm/tsmcN65/../models/spectre/crn65gplus_2d5_lk_v1d0.scs" section=tt_bip_npn
include "/home/nano01/a/agrawa64/mosis_65nm/mosis_65nm/tsmcN65/../models/spectre/crn65gplus_2d5_lk_v1d0.scs" section=tt_33
include "/home/nano01/a/agrawa64/mosis_65nm/mosis_65nm/tsmcN65/../models/spectre/crn65gplus_2d5_lk_v1d0.scs" section=tt_rfrtmom
include "/home/nano01/a/agrawa64/mosis_65nm/mosis_65nm/tsmcN65/../models/spectre/crn65gplus_2d5_lk_v1d0.scs" section=tt_mos_cap_25
include "/home/nano01/a/agrawa64/mosis_65nm/mosis_65nm/tsmcN65/../models/spectre/crn65gplus_2d5_lk_v1d0.scs" section=tt_18
include "/home/nano01/a/agrawa64/mosis_65nm/mosis_65nm/tsmcN65/../models/spectre/crn65gplus_2d5_lk_v1d0.scs" section=tt_disres
include "/home/nano01/a/agrawa64/mosis_65nm/mosis_65nm/tsmcN65/../models/spectre/crn65gplus_2d5_lk_v1d0.scs" section=tt_res
include "/home/nano01/a/agrawa64/mosis_65nm/mosis_65nm/tsmcN65/../models/spectre/crn65gplus_2d5_lk_v1d0.scs" section=tt_dio_na
include "/home/nano01/a/agrawa64/mosis_65nm/mosis_65nm/tsmcN65/../models/spectre/crn65gplus_2d5_lk_v1d0.scs" section=tt_rfmos_33
include "/home/nano01/a/agrawa64/mosis_65nm/mosis_65nm/tsmcN65/../models/spectre/crn65gplus_2d5_lk_v1d0.scs" section=tt_dio_hvt
include "/home/nano01/a/agrawa64/mosis_65nm/mosis_65nm/tsmcN65/../models/spectre/crn65gplus_2d5_lk_v1d0.scs" section=tt_rfmvar
include "/home/nano01/a/agrawa64/mosis_65nm/mosis_65nm/tsmcN65/../models/spectre/crn65gplus_2d5_lk_v1d0.scs" section=tt_rfmos_18
include "/home/nano01/a/agrawa64/mosis_65nm/mosis_65nm/tsmcN65/../models/spectre/crn65gplus_2d5_lk_v1d0.scs" section=tt_na
include "/home/nano01/a/agrawa64/mosis_65nm/mosis_65nm/tsmcN65/../models/spectre/crn65gplus_2d5_lk_v1d0.scs" section=tt_dio_na33
include "/home/nano01/a/agrawa64/mosis_65nm/mosis_65nm/tsmcN65/../models/spectre/crn65gplus_2d5_lk_v1d0.scs" section=tt_dio_lvt
include "/home/nano01/a/agrawa64/mosis_65nm/mosis_65nm/tsmcN65/../models/spectre/crn65gplus_2d5_lk_v1d0.scs" section=tt_rfres_sa
include "/home/nano01/a/agrawa64/mosis_65nm/mosis_65nm/tsmcN65/../models/spectre/crn65gplus_2d5_lk_v1d0.scs" section=tt_na33
include "/home/nano01/a/agrawa64/mosis_65nm/mosis_65nm/tsmcN65/../models/spectre/crn65gplus_2d5_lk_v1d0.scs" section=tt_dio_esd
include "/home/nano01/a/agrawa64/mosis_65nm/mosis_65nm/tsmcN65/../models/spectre/crn65gplus_2d5_lk_v1d0.scs" section=tt_rfmim
include "/home/nano01/a/agrawa64/mosis_65nm/mosis_65nm/tsmcN65/../models/spectre/crn65gplus_2d5_lk_v1d0.scs" section=tt_dio_25od33
include "/home/nano01/a/agrawa64/mosis_65nm/mosis_65nm/tsmcN65/../models/spectre/crn65gplus_2d5_lk_v1d0.scs" section=tt_25od33
include "/home/nano01/a/agrawa64/mosis_65nm/mosis_65nm/tsmcN65/../models/spectre/crn65gplus_2d5_lk_v1d0.scs" section=tt
include "/home/nano01/a/agrawa64/mosis_65nm/mosis_65nm/tsmcN65/../models/spectre/crn65gplus_2d5_lk_v1d0.scs" section=tt_mos_cap
include "/home/nano01/a/agrawa64/mosis_65nm/mosis_65nm/tsmcN65/../models/spectre/crn65gplus_2d5_lk_v1d0.scs" section=tt_dio_25
include "/home/nano01/a/agrawa64/mosis_65nm/mosis_65nm/tsmcN65/../models/spectre/crn65gplus_2d5_lk_v1d0.scs" section=tt_dio_25ud18
include "/home/nano01/a/agrawa64/mosis_65nm/mosis_65nm/tsmcN65/../models/spectre/crn65gplus_2d5_lk_v1d0.scs" section=tt_25
include "/home/nano01/a/agrawa64/mosis_65nm/mosis_65nm/tsmcN65/../models/spectre/crn65gplus_2d5_lk_v1d0.scs" section=tt_rfmos
include "/home/nano01/a/agrawa64/mosis_65nm/mosis_65nm/tsmcN65/../models/spectre/crn65gplus_2d5_lk_v1d0.scs" section=tt_25ud18
include "/home/nano01/a/agrawa64/mosis_65nm/mosis_65nm/tsmcN65/../models/spectre/crn65gplus_2d5_lk_v1d0.scs" section=tt_dio_na25od33
include "/home/nano01/a/agrawa64/mosis_65nm/mosis_65nm/tsmcN65/../models/spectre/crn65gplus_2d5_lk_v1d0.scs" section=tt_rfjvar
include "/home/nano01/a/agrawa64/mosis_65nm/mosis_65nm/tsmcN65/../models/spectre/crn65gplus_2d5_lk_v1d0.scs" section=tt_rfmos_25
include "/home/nano01/a/agrawa64/mosis_65nm/mosis_65nm/tsmcN65/../models/spectre/crn65gplus_2d5_lk_v1d0.scs" section=tt_rtmom
include "/home/nano01/a/agrawa64/mosis_65nm/mosis_65nm/tsmcN65/../models/spectre/crn65gplus_2d5_lk_v1d0.scs" section=tt_na25od33
include "/home/nano01/a/agrawa64/mosis_65nm/mosis_65nm/tsmcN65/../models/spectre/crn65gplus_2d5_lk_v1d0.scs" section=tt_dio_na25
include "/home/nano01/a/agrawa64/mosis_65nm/mosis_65nm/tsmcN65/../models/spectre/crn65gplus_2d5_lk_v1d0.scs" section=tt_rfres_rpo
include "/home/nano01/a/agrawa64/mosis_65nm/mosis_65nm/tsmcN65/../models/spectre/crn65gplus_2d5_lk_v1d0.scs" section=tt_hvt
include "/home/nano01/a/agrawa64/mosis_65nm/mosis_65nm/tsmcN65/../models/spectre/crn65gplus_2d5_lk_v1d0.scs" section=tt_rfind
include "/home/nano01/a/agrawa64/mosis_65nm/mosis_65nm/tsmcN65/../models/spectre/crn65gplus_2d5_lk_v1d0.scs" section=tt_rfmvar_25
include "/home/nano01/a/agrawa64/mosis_65nm/mosis_65nm/tsmcN65/../models/spectre/crn65gplus_2d5_lk_v1d0.scs" section=tt_na25
include "/home/nano01/a/agrawa64/mosis_65nm/mosis_65nm/tsmcN65/../models/spectre/crn65gplus_2d5_lk_v1d0.scs" section=tt_lvt
include "/home/nano01/a/agrawa64/mosis_65nm/mosis_65nm/tsmcN65/../models/spectre/crn65gplus_2d5_lk_v1d0.scs" section=stat_mis

// Sangamesh_SRAM/6T_cell/schematic
subckt Sangamesh_SRAM_6T_cell_schematic BL BLB WL gnd vdd
    M6 (qb q vdd vdd) pch_mac l=60n w=120.0n multi=1 nf=1 sigma=1 mismatchflag=1
    M7 (q qb vdd vdd) pch_mac l=60n w=120.0n multi=1 nf=1 sigma=1 mismatchflag=1
    M11 (q WL BL gnd) nch_mac l=60n w=200n multi=1 nf=1 sigma=1 mismatchflag=1
    M10 (q qb gnd gnd) nch_mac l=60n w=480.0n multi=1 nf=4 sigma=1 mismatchflag=1
    M8 (qb WL BLB gnd) nch_mac l=60n w=200n multi=1 nf=1 sigma=1 mismatchflag=1
    M9 (qb q gnd gnd) nch_mac l=60n w=480.0n multi=1 nf=4 sigma=1 mismatchflag=1
ends Sangamesh_SRAM_6T_cell_schematic

// Sangamesh_SRAM/Precharge/schematic
subckt Precharge Vpre VpreL VpreR vdd
    M2 (VpreL Vpre VpreR vdd) pch_mac l=60n w=200n multi=1 nf=1 sigma=1 mismatchflag=1
    M1 (VpreR Vpre vdd vdd) pch_mac l=60n w=1.2u multi=1 nf=2 sigma=1 mismatchflag=1
    M0 (VpreL Vpre vdd vdd) pch_mac l=60n w=1.2u multi=1 nf=2 sigma=1 mismatchflag=1
ends Precharge

// Sangamesh_3TDRAM/INV/schematic
subckt INV A Out Vdd gnd
    M4 (Out A gnd gnd) nch_mac l=60n w=120.0n multi=1 nf=1 sigma=1 mismatchflag=1
    M5 (Out A Vdd Vdd) pch_mac l=60n w=120.0n multi=1 nf=1 sigma=1 mismatchflag=1
ends INV

// Sangamesh_SRAM/Latched_Comparator_nmos/schematic
subckt Latched_Comparator_nmos Out\+ clk1 clk2 gnd in\+ in\- vdd
    I2 (net059 Out\+ vdd gnd) INV
    I1 (clk2 net062 vdd gnd) INV
    M42 (net059 net062 net060 vdd) pch_mac l=60n w=120.0n multi=1 nf=1 sigma=1 mismatchflag=1
    M41 (net055 clk1 vdd vdd) pch_mac l=60n w=600n multi=1 nf=3 sigma=1 mismatchflag=1
    M37 (net64 in\+ net055 vdd) pch_mac l=60n w=800n multi=1 nf=4 sigma=1 mismatchflag=1
    M36 (net052 net060 net75 vdd) pch_mac l=60n w=800n multi=1 nf=4 sigma=1 mismatchflag=1
    M35 (net060 net052 net64 vdd) pch_mac l=60n w=800n multi=1 nf=4 sigma=1 mismatchflag=1
    M40 (net75 in\- net055 vdd) pch_mac l=60n w=800n multi=1 nf=4 sigma=1 mismatchflag=1
    M43 (net052 vdd net063 vdd) pch_mac l=60n w=120.0n multi=1 nf=1 sigma=1 mismatchflag=1
    M67 (net063 gnd net052 gnd) nch_mac l=60n w=120.0n multi=1 nf=1 sigma=1 mismatchflag=1
    M66 (net060 clk2 net059 gnd) nch_mac l=60n w=120.0n multi=1 nf=1 sigma=1 mismatchflag=1
    M65 (net75 clk1 gnd gnd) nch_mac l=60n w=120.0n multi=1 nf=1 sigma=1 mismatchflag=0
    M64 (net64 clk1 gnd gnd) nch_mac l=60n w=120.0n multi=1 nf=1 sigma=1 mismatchflag=0
    M62 (net060 clk1 gnd gnd) nch_mac l=60n w=120.0n multi=1 nf=1 sigma=1 mismatchflag=0
    M63 (net052 clk1 gnd gnd) nch_mac l=60n w=120.0n multi=1 nf=1 sigma=1 mismatchflag=0
    M61 (net052 net060 gnd gnd) nch_mac l=60n w=800n multi=1 nf=4 sigma=1 mismatchflag=0
    M60 (net060 net052 gnd gnd) nch_mac l=60n w=800n multi=1 nf=4 sigma=1 mismatchflag=0
ends Latched_Comparator_nmos

// Sangamesh_SRAM/AND2/schematic
subckt AND2 A B Out gnd vdd
    M24 (net34 A net37 gnd) nch_mac l=60n w=120.0n multi=1 nf=1 sigma=1 mismatchflag=1
    M29 (Out net34 gnd gnd) nch_mac l=60n w=120.0n multi=1 nf=1 sigma=1 mismatchflag=1
    M25 (net37 B gnd gnd) nch_mac l=60n w=120.0n multi=1 nf=1 sigma=1 mismatchflag=1
    M28 (Out net34 vdd vdd) pch_mac l=60n w=120.0n multi=1 nf=1 sigma=1 mismatchflag=1
    M27 (net34 B vdd vdd) pch_mac l=60n w=120.0n multi=1 nf=1 sigma=1 mismatchflag=1
    M26 (net34 A vdd vdd) pch_mac l=60n w=120.0n multi=1 nf=1 sigma=1 mismatchflag=1
ends AND2

// Sangamesh_SRAM/INV/schematic
subckt INV_schematic A Out Vdd gnd
    M4 (Out A gnd gnd) nch_mac l=60n w=120.0n multi=1 nf=1 sigma=1 mismatchflag=1
    M5 (Out A Vdd Vdd) pch_mac l=60n w=120.0n multi=1 nf=1 sigma=1 mismatchflag=1
ends INV_schematic

// Sangamesh_SRAM/NOR3/schematic
subckt NOR3 A B C Out Vdd gnd
    M9 (Out C gnd gnd) nch_mac l=60n w=120.0n multi=1 nf=1 sigma=1 mismatchflag=1
    M7 (Out B gnd gnd) nch_mac l=60n w=120.0n multi=1 nf=1 sigma=1 mismatchflag=1
    M6 (Out A gnd gnd) nch_mac l=60n w=120.0n multi=1 nf=1 sigma=1 mismatchflag=1
    M11 (net39 A Vdd Vdd) pch_mac l=60n w=120.0n multi=1 nf=1 sigma=1 mismatchflag=1
    M10 (net38 B net39 Vdd) pch_mac l=60n w=120.0n multi=1 nf=1 sigma=1 mismatchflag=1
    M12 (Out C net38 Vdd) pch_mac l=60n w=120.0n multi=1 nf=1 sigma=1 mismatchflag=1
ends NOR3

// Sangamesh_SRAM/Analog_Mux/schematic
subckt Analog_Mux S Vin0 Vin1 Vout gnd vdd
    M2 (Vin1 S Vout gnd) nch_mac l=60n w=120.0n multi=1 nf=1 sigma=1 mismatchflag=1
    M0 (net23 S gnd gnd) nch_mac l=60n w=120.0n multi=1 nf=1 sigma=1 mismatchflag=1
    M84 (Vin0 net23 Vout gnd) nch_mac l=60n w=120.0n multi=1 nf=1 sigma=1 mismatchflag=1
    M3 (Vout net23 Vin1 vdd) pch_mac l=60n w=120.0n multi=1 nf=1 sigma=1 mismatchflag=1
    M1 (net23 S vdd vdd) pch_mac l=60n w=120.0n multi=1 nf=1 sigma=1 mismatchflag=1
    M85 (Vout S Vin0 vdd) pch_mac l=60n w=120.0n multi=1 nf=1 sigma=1 mismatchflag=1
ends Analog_Mux

// Sangamesh_SRAM/NAND3/schematic
subckt NAND3 A B C Out gnd vdd
    M2 (net16 C gnd gnd) nch_mac l=60n w=120.0n multi=1 nf=1 sigma=1 mismatchflag=1
    M1 (net15 B net16 gnd) nch_mac l=60n w=120.0n multi=1 nf=1 sigma=1 mismatchflag=1
    M0 (Out A net15 gnd) nch_mac l=60n w=120.0n multi=1 nf=1 sigma=1 mismatchflag=1
    M5 (Out C vdd vdd) pch_mac l=60n w=120.0n multi=1 nf=1 sigma=1 mismatchflag=1
    M4 (Out B vdd vdd) pch_mac l=60n w=120.0n multi=1 nf=1 sigma=1 mismatchflag=1
    M3 (Out A vdd vdd) pch_mac l=60n w=120.0n multi=1 nf=1 sigma=1 mismatchflag=1
ends NAND3

// Sangamesh_SRAM/DFF/schematic
subckt DFF Clk D gnd Q Qb Reset Set Vdd
    I10 (Q net13 Reset Qb gnd Vdd) NAND3
    I9 (Set net7 Qb Q gnd Vdd) NAND3
    I8 (net13 D Reset net16 gnd Vdd) NAND3
    I7 (net7 Clk net16 net13 gnd Vdd) NAND3
    I6 (net21 Clk Reset net7 gnd Vdd) NAND3
    I0 (Set net16 net7 net21 gnd Vdd) NAND3
ends DFF

// Sangamesh_SRAM/OR2/schematic
subckt OR2 A B Out Vdd gnd
    M4 (Out net8 gnd gnd) nch_mac l=60n w=120.0n multi=1 nf=1 sigma=1 mismatchflag=1
    M1 (net8 B gnd gnd) nch_mac l=60n w=120.0n multi=1 nf=1 sigma=1 mismatchflag=1
    M0 (net8 A gnd gnd) nch_mac l=60n w=120.0n multi=1 nf=1 sigma=1 mismatchflag=1
    M5 (Out net8 Vdd Vdd) pch_mac l=60n w=120.0n multi=1 nf=1 sigma=1 mismatchflag=1
    M3 (net14 A Vdd Vdd) pch_mac l=60n w=120.0n multi=1 nf=1 sigma=1 mismatchflag=1
    M2 (net8 B net14 Vdd) pch_mac l=60n w=120.0n multi=1 nf=1 sigma=1 mismatchflag=1
ends OR2

// Sangamesh_SRAM/4b_Digital_logic/schematic
subckt Sangamesh_SRAM_4b_Digital_logic_schematic Clk_ShifReg CompOut R0 R0b R1 R1b R2 R2b R3 R3b Reset Reset_ShiftReg Set Vdd clk gnd
    I18 (D3 net047 Vdd gnd) INV_schematic
    I17 (D0 net048 Vdd gnd) INV_schematic
    I12 (D1 net049 Vdd gnd) INV_schematic
    I11 (D2 net050 Vdd gnd) INV_schematic
    I16 (net047 CompOut R3b net207 Vdd gnd) NOR3
    I26 (net050 CompOut R2b net210 Vdd gnd) NOR3
    I23 (net049 CompOut R1b net209 Vdd gnd) NOR3
    I32 (net048 CompOut R0b net208 Vdd gnd) NOR3
    I14 (net207 net211 gnd net203 gnd Vdd) Analog_Mux
    I24 (net210 net214 gnd net206 gnd Vdd) Analog_Mux
    I20 (net209 net213 gnd net205 gnd Vdd) Analog_Mux
    I30 (net208 net212 gnd net204 gnd Vdd) Analog_Mux
    I5 (Clk_ShifReg D0 gnd D net219 Vdd Reset_ShiftReg Vdd) DFF
    I0 (Clk_ShifReg D1 gnd D0 net220 Reset_ShiftReg Vdd Vdd) DFF
    I3 (Clk_ShifReg D2 gnd D1 net221 Reset_ShiftReg Vdd Vdd) DFF
    I2 (Clk_ShifReg D3 gnd D2 net222 Reset_ShiftReg Vdd Vdd) DFF
    I1 (Clk_ShifReg D gnd D3 net223 Reset_ShiftReg Vdd Vdd) DFF
    I15 (clk net203 gnd R3 R3b Reset Set Vdd) DFF
    I25 (clk net206 gnd R2 R2b Reset Set Vdd) DFF
    I21 (clk net205 gnd R1 R1b Reset Set Vdd) DFF
    I31 (clk net204 gnd R0 R0b Reset Set Vdd) DFF
    I13 (R3 D3 net211 Vdd gnd) OR2
    I22 (R2 D2 net214 Vdd gnd) OR2
    I19 (R1 D1 net213 Vdd gnd) OR2
    I29 (R0 D0 net212 Vdd gnd) OR2
ends Sangamesh_SRAM_4b_Digital_logic_schematic

// Sangamesh_SRAM/6T_MAC/schematic
M12 (product net021 sample gnd) nch_mac l=60n w=120.0n multi=1 nf=1 sigma=1 mismatchflag=1
M26 (net043 d1 vdd_adc gnd) nch_mac l=60n w=800n multi=1 nf=4 sigma=1 mismatchflag=1
M30 (net045 d0 vdd_adc gnd) nch_mac l=60n w=800n multi=1 nf=4 sigma=1 mismatchflag=1
M21 (net046 d3 vdd_adc gnd) nch_mac l=60n w=800n multi=1 nf=4 sigma=1 mismatchflag=1
M17 (net042 d2 vdd_adc gnd) nch_mac l=60n w=800n multi=1 nf=4 sigma=1 mismatchflag=1
M23 (vss_adc D3 net046 gnd) nch_mac l=60n w=1.2u multi=1 nf=6 sigma=1 mismatchflag=1
M19 (net042 D2 vss_adc gnd) nch_mac l=60n w=800n multi=1 nf=4 sigma=1 mismatchflag=1
M24 (net043 D1 vss_adc gnd) nch_mac l=60n w=400n multi=1 nf=2 sigma=1 mismatchflag=1
M28 (net045 D0 vss_adc gnd) nch_mac l=60n w=200n multi=1 nf=1 sigma=1 mismatchflag=1
M14 (net021 ensample gnd gnd) nch_mac l=60n w=120.0n multi=1 nf=1 sigma=1 mismatchflag=1
M8 (BLB0 en_sharing product gnd) nch_mac l=60n w=120.0n multi=1 nf=1 sigma=1 mismatchflag=1
M6 (BLB1 en_sharing product gnd) nch_mac l=60n w=120.0n multi=1 nf=1 sigma=1 mismatchflag=1
M2 (BLB3 en_sharing product gnd) nch_mac l=60n w=120.0n multi=1 nf=1 sigma=1 mismatchflag=1
M4 (BLB2 en_sharing product gnd) nch_mac l=60n w=120.0n multi=1 nf=1 sigma=1 mismatchflag=1
M10 (en_sharing_b en_sharing gnd gnd) nch_mac l=60n w=120.0n multi=1 nf=1 sigma=1 mismatchflag=1
M25 (vss_adc d1 net043 vdd_pre) pch_mac l=60n w=800n multi=1 nf=4 sigma=1 mismatchflag=1
M29 (vss_adc d0 net045 vdd_pre) pch_mac l=60n w=800n multi=1 nf=4 sigma=1 mismatchflag=1
M22 (vss_adc d3 net046 vdd_pre) pch_mac l=60n w=800n multi=1 nf=4 sigma=1 mismatchflag=1
M18 (vss_adc d2 net042 vdd_pre) pch_mac l=60n w=800n multi=1 nf=4 sigma=1 mismatchflag=1
M20 (net046 D3 vdd_adc vdd_pre) pch_mac l=60n w=1.2u multi=1 nf=6 sigma=1 mismatchflag=1
M16 (vdd_adc D2 net042 vdd_pre) pch_mac l=60n w=800n multi=1 nf=4 sigma=1 mismatchflag=1
M27 (vdd_adc D1 net043 vdd_pre) pch_mac l=60n w=400n multi=1 nf=2 sigma=1 mismatchflag=1
M31 (vdd_adc D0 net045 vdd_pre) pch_mac l=60n w=200n multi=1 nf=1 sigma=1 mismatchflag=1
M11 (product ensample sample vdd_pre) pch_mac l=60n w=120.0n multi=1 nf=1 sigma=1 mismatchflag=1
M13 (net021 ensample vdd_pre vdd_pre) pch_mac l=60n w=120.0n multi=1 nf=1 sigma=1 mismatchflag=1
M9 (en_sharing_b en_sharing vdd_pre vdd_pre) pch_mac l=60n w=120.0n multi=1 nf=1 sigma=1 mismatchflag=1
M5 (product en_sharing_b BLB1 vdd_pre) pch_mac l=60n w=120.0n multi=1 nf=1 sigma=1 mismatchflag=1
M1 (product en_sharing_b BLB3 vdd_pre) pch_mac l=60n w=120.0n multi=1 nf=1 sigma=1 mismatchflag=1
M7 (product en_sharing_b BLB0 vdd_pre) pch_mac l=60n w=120.0n multi=1 nf=1 sigma=1 mismatchflag=1
M3 (product en_sharing_b BLB2 vdd_pre) pch_mac l=60n w=120.0n multi=1 nf=1 sigma=1 mismatchflag=1
C5 (BLB0 gnd) capacitor c=50f
C0 (BLB3 gnd) capacitor c=50f
C4 (BLB1 gnd) capacitor c=50f
C7 (BL1 gnd) capacitor c=50f
C6 (BL0 gnd) capacitor c=50f
C2 (BL2 gnd) capacitor c=50f
C3 (BLB2 gnd) capacitor c=50f
C1 (BL3 gnd) capacitor c=50f
I3 (Vpre0 BL0 BLB0 vdd_pre) Precharge
I2 (Vpre1 BL1 BLB1 vdd_pre) Precharge
I1 (Vpre2 BL2 BLB2 vdd_pre) Precharge
I0 (Vpre3 BL3 BLB3 vdd_pre) Precharge

//SK Array of 25 rows
I_1_1 (BL3 BLB3 WL1 gnd vdd) Sangamesh_SRAM_6T_cell_schematic
I_1_2 (BL2 BLB2 WL1 gnd vdd) Sangamesh_SRAM_6T_cell_schematic
I_1_3 (BL1 BLB1 WL1 gnd vdd) Sangamesh_SRAM_6T_cell_schematic
I_1_4 (BL0 BLB0 WL1 gnd vdd) Sangamesh_SRAM_6T_cell_schematic
I_2_1 (BL3 BLB3 WL2 gnd vdd) Sangamesh_SRAM_6T_cell_schematic
I_2_2 (BL2 BLB2 WL2 gnd vdd) Sangamesh_SRAM_6T_cell_schematic
I_2_3 (BL1 BLB1 WL2 gnd vdd) Sangamesh_SRAM_6T_cell_schematic
I_2_4 (BL0 BLB0 WL2 gnd vdd) Sangamesh_SRAM_6T_cell_schematic
I_3_1 (BL3 BLB3 WL3 gnd vdd) Sangamesh_SRAM_6T_cell_schematic
I_3_2 (BL2 BLB2 WL3 gnd vdd) Sangamesh_SRAM_6T_cell_schematic
I_3_3 (BL1 BLB1 WL3 gnd vdd) Sangamesh_SRAM_6T_cell_schematic
I_3_4 (BL0 BLB0 WL3 gnd vdd) Sangamesh_SRAM_6T_cell_schematic
I_4_1 (BL3 BLB3 WL4 gnd vdd) Sangamesh_SRAM_6T_cell_schematic
I_4_2 (BL2 BLB2 WL4 gnd vdd) Sangamesh_SRAM_6T_cell_schematic
I_4_3 (BL1 BLB1 WL4 gnd vdd) Sangamesh_SRAM_6T_cell_schematic
I_4_4 (BL0 BLB0 WL4 gnd vdd) Sangamesh_SRAM_6T_cell_schematic
I_5_1 (BL3 BLB3 WL5 gnd vdd) Sangamesh_SRAM_6T_cell_schematic
I_5_2 (BL2 BLB2 WL5 gnd vdd) Sangamesh_SRAM_6T_cell_schematic
I_5_3 (BL1 BLB1 WL5 gnd vdd) Sangamesh_SRAM_6T_cell_schematic
I_5_4 (BL0 BLB0 WL5 gnd vdd) Sangamesh_SRAM_6T_cell_schematic
I_6_1 (BL3 BLB3 WL6 gnd vdd) Sangamesh_SRAM_6T_cell_schematic
I_6_2 (BL2 BLB2 WL6 gnd vdd) Sangamesh_SRAM_6T_cell_schematic
I_6_3 (BL1 BLB1 WL6 gnd vdd) Sangamesh_SRAM_6T_cell_schematic
I_6_4 (BL0 BLB0 WL6 gnd vdd) Sangamesh_SRAM_6T_cell_schematic
I_7_1 (BL3 BLB3 WL7 gnd vdd) Sangamesh_SRAM_6T_cell_schematic
I_7_2 (BL2 BLB2 WL7 gnd vdd) Sangamesh_SRAM_6T_cell_schematic
I_7_3 (BL1 BLB1 WL7 gnd vdd) Sangamesh_SRAM_6T_cell_schematic
I_7_4 (BL0 BLB0 WL7 gnd vdd) Sangamesh_SRAM_6T_cell_schematic
I_8_1 (BL3 BLB3 WL8 gnd vdd) Sangamesh_SRAM_6T_cell_schematic
I_8_2 (BL2 BLB2 WL8 gnd vdd) Sangamesh_SRAM_6T_cell_schematic
I_8_3 (BL1 BLB1 WL8 gnd vdd) Sangamesh_SRAM_6T_cell_schematic
I_8_4 (BL0 BLB0 WL8 gnd vdd) Sangamesh_SRAM_6T_cell_schematic
I_9_1 (BL3 BLB3 WL9 gnd vdd) Sangamesh_SRAM_6T_cell_schematic
I_9_2 (BL2 BLB2 WL9 gnd vdd) Sangamesh_SRAM_6T_cell_schematic
I_9_3 (BL1 BLB1 WL9 gnd vdd) Sangamesh_SRAM_6T_cell_schematic
I_9_4 (BL0 BLB0 WL9 gnd vdd) Sangamesh_SRAM_6T_cell_schematic
I_10_1 (BL3 BLB3 WL10 gnd vdd) Sangamesh_SRAM_6T_cell_schematic
I_10_2 (BL2 BLB2 WL10 gnd vdd) Sangamesh_SRAM_6T_cell_schematic
I_10_3 (BL1 BLB1 WL10 gnd vdd) Sangamesh_SRAM_6T_cell_schematic
I_10_4 (BL0 BLB0 WL10 gnd vdd) Sangamesh_SRAM_6T_cell_schematic
I_11_1 (BL3 BLB3 WL11 gnd vdd) Sangamesh_SRAM_6T_cell_schematic
I_11_2 (BL2 BLB2 WL11 gnd vdd) Sangamesh_SRAM_6T_cell_schematic
I_11_3 (BL1 BLB1 WL11 gnd vdd) Sangamesh_SRAM_6T_cell_schematic
I_11_4 (BL0 BLB0 WL11 gnd vdd) Sangamesh_SRAM_6T_cell_schematic
I_12_1 (BL3 BLB3 WL12 gnd vdd) Sangamesh_SRAM_6T_cell_schematic
I_12_2 (BL2 BLB2 WL12 gnd vdd) Sangamesh_SRAM_6T_cell_schematic
I_12_3 (BL1 BLB1 WL12 gnd vdd) Sangamesh_SRAM_6T_cell_schematic
I_12_4 (BL0 BLB0 WL12 gnd vdd) Sangamesh_SRAM_6T_cell_schematic
I_13_1 (BL3 BLB3 WL13 gnd vdd) Sangamesh_SRAM_6T_cell_schematic
I_13_2 (BL2 BLB2 WL13 gnd vdd) Sangamesh_SRAM_6T_cell_schematic
I_13_3 (BL1 BLB1 WL13 gnd vdd) Sangamesh_SRAM_6T_cell_schematic
I_13_4 (BL0 BLB0 WL13 gnd vdd) Sangamesh_SRAM_6T_cell_schematic
I_14_1 (BL3 BLB3 WL14 gnd vdd) Sangamesh_SRAM_6T_cell_schematic
I_14_2 (BL2 BLB2 WL14 gnd vdd) Sangamesh_SRAM_6T_cell_schematic
I_14_3 (BL1 BLB1 WL14 gnd vdd) Sangamesh_SRAM_6T_cell_schematic
I_14_4 (BL0 BLB0 WL14 gnd vdd) Sangamesh_SRAM_6T_cell_schematic
I_15_1 (BL3 BLB3 WL15 gnd vdd) Sangamesh_SRAM_6T_cell_schematic
I_15_2 (BL2 BLB2 WL15 gnd vdd) Sangamesh_SRAM_6T_cell_schematic
I_15_3 (BL1 BLB1 WL15 gnd vdd) Sangamesh_SRAM_6T_cell_schematic
I_15_4 (BL0 BLB0 WL15 gnd vdd) Sangamesh_SRAM_6T_cell_schematic
I_16_1 (BL3 BLB3 WL16 gnd vdd) Sangamesh_SRAM_6T_cell_schematic
I_16_2 (BL2 BLB2 WL16 gnd vdd) Sangamesh_SRAM_6T_cell_schematic
I_16_3 (BL1 BLB1 WL16 gnd vdd) Sangamesh_SRAM_6T_cell_schematic
I_16_4 (BL0 BLB0 WL16 gnd vdd) Sangamesh_SRAM_6T_cell_schematic
I_17_1 (BL3 BLB3 WL17 gnd vdd) Sangamesh_SRAM_6T_cell_schematic
I_17_2 (BL2 BLB2 WL17 gnd vdd) Sangamesh_SRAM_6T_cell_schematic
I_17_3 (BL1 BLB1 WL17 gnd vdd) Sangamesh_SRAM_6T_cell_schematic
I_17_4 (BL0 BLB0 WL17 gnd vdd) Sangamesh_SRAM_6T_cell_schematic
I_18_1 (BL3 BLB3 WL18 gnd vdd) Sangamesh_SRAM_6T_cell_schematic
I_18_2 (BL2 BLB2 WL18 gnd vdd) Sangamesh_SRAM_6T_cell_schematic
I_18_3 (BL1 BLB1 WL18 gnd vdd) Sangamesh_SRAM_6T_cell_schematic
I_18_4 (BL0 BLB0 WL18 gnd vdd) Sangamesh_SRAM_6T_cell_schematic
I_19_1 (BL3 BLB3 WL19 gnd vdd) Sangamesh_SRAM_6T_cell_schematic
I_19_2 (BL2 BLB2 WL19 gnd vdd) Sangamesh_SRAM_6T_cell_schematic
I_19_3 (BL1 BLB1 WL19 gnd vdd) Sangamesh_SRAM_6T_cell_schematic
I_19_4 (BL0 BLB0 WL19 gnd vdd) Sangamesh_SRAM_6T_cell_schematic
I_20_1 (BL3 BLB3 WL20 gnd vdd) Sangamesh_SRAM_6T_cell_schematic
I_20_2 (BL2 BLB2 WL20 gnd vdd) Sangamesh_SRAM_6T_cell_schematic
I_20_3 (BL1 BLB1 WL20 gnd vdd) Sangamesh_SRAM_6T_cell_schematic
I_20_4 (BL0 BLB0 WL20 gnd vdd) Sangamesh_SRAM_6T_cell_schematic
I_21_1 (BL3 BLB3 WL21 gnd vdd) Sangamesh_SRAM_6T_cell_schematic
I_21_2 (BL2 BLB2 WL21 gnd vdd) Sangamesh_SRAM_6T_cell_schematic
I_21_3 (BL1 BLB1 WL21 gnd vdd) Sangamesh_SRAM_6T_cell_schematic
I_21_4 (BL0 BLB0 WL21 gnd vdd) Sangamesh_SRAM_6T_cell_schematic
I_22_1 (BL3 BLB3 WL22 gnd vdd) Sangamesh_SRAM_6T_cell_schematic
I_22_2 (BL2 BLB2 WL22 gnd vdd) Sangamesh_SRAM_6T_cell_schematic
I_22_3 (BL1 BLB1 WL22 gnd vdd) Sangamesh_SRAM_6T_cell_schematic
I_22_4 (BL0 BLB0 WL22 gnd vdd) Sangamesh_SRAM_6T_cell_schematic
I_23_1 (BL3 BLB3 WL23 gnd vdd) Sangamesh_SRAM_6T_cell_schematic
I_23_2 (BL2 BLB2 WL23 gnd vdd) Sangamesh_SRAM_6T_cell_schematic
I_23_3 (BL1 BLB1 WL23 gnd vdd) Sangamesh_SRAM_6T_cell_schematic
I_23_4 (BL0 BLB0 WL23 gnd vdd) Sangamesh_SRAM_6T_cell_schematic
I_24_1 (BL3 BLB3 WL24 gnd vdd) Sangamesh_SRAM_6T_cell_schematic
I_24_2 (BL2 BLB2 WL24 gnd vdd) Sangamesh_SRAM_6T_cell_schematic
I_24_3 (BL1 BLB1 WL24 gnd vdd) Sangamesh_SRAM_6T_cell_schematic
I_24_4 (BL0 BLB0 WL24 gnd vdd) Sangamesh_SRAM_6T_cell_schematic
I_25_1 (BL3 BLB3 WL25 gnd vdd) Sangamesh_SRAM_6T_cell_schematic
I_25_2 (BL2 BLB2 WL25 gnd vdd) Sangamesh_SRAM_6T_cell_schematic
I_25_3 (BL1 BLB1 WL25 gnd vdd) Sangamesh_SRAM_6T_cell_schematic
I_25_4 (BL0 BLB0 WL25 gnd vdd) Sangamesh_SRAM_6T_cell_schematic
//SK End array of 25 rows

C20 (sample net102) mimcap_sin lt=2u wt=2u mimflag=3 mf=1 mismatchflag=0
C21 (net102 net103) mimcap_sin lt=2u wt=2u mimflag=3 mf=1 mismatchflag=0
C8 (accumulation gnd) mimcap_sin lt=6.87u wt=6.87u mimflag=3 mf=1 mismatchflag=0
C23 (net103 net101) mimcap_sin lt=2u wt=2u mimflag=3 mf=1 mismatchflag=0
C22 (net101 gnd) mimcap_sin lt=2u wt=2u mimflag=3 mf=1 mismatchflag=0
M15 (sample enacc accumulation vdd_pre) pch_18_mac l=260n w=400n multi=1 nf=1 sigma=1 mismatchflag=1
I27 (compout net081 net087 gnd Vx accumulation vdd_pre) Latched_Comparator_nmos
C12 (net046 Vx net046) moscap_rf25 wr=700n lr=700n br=2 gr=8 m=1
C15 (net042 Vx net042) moscap_rf25 wr=630.0n lr=630.0n br=2 gr=4 m=1
C14 (net043 Vx net043) moscap_rf25 wr=700n lr=700n br=2 gr=1 m=1
C9 (net067 Vx net067) moscap_rf25 wr=500n lr=500n br=2 gr=1 m=1
C13 (net045 net067 net045) moscap_rf25 wr=500n lr=500n br=2 gr=1 m=1
I30 (ADC_en clk_ShiftReg net086 gnd vdd_pre) AND2
I32 (ADC_en clk_logic net088 gnd vdd_pre) AND2
I29 (ADC_en clk_SA net081 gnd vdd_pre) AND2
I31 (ADC_en Output_valid net087 gnd vdd_pre) AND2
I28 (net086 compout D0 d0 D1 d1 D2 d2 D3 d3 Reset Reset_ShiftReg vdd_pre vdd_pre net088 gnd) Sangamesh_SRAM_4b_Digital_logic_schematic

//SK control signals
//Power rails
Vvdd (vdd 0) vsource dc=1
Vvdd_pre (vdd_pre 0) vsource dc=1.2
Vground (gnd 0) vsource dc=0
// Precharge Signal
Vvpre0 (Vpre0 0) vsource type=pwl wave=[0 0 1.35n 0 1.351n 1.2 1.6n 1.2 1.601n 0 2.35n 0 2.351n 1.2 2.6n 1.2 2.601n 0 3.35n 0 3.351n 1.2 3.6n 1.2 3.601n 0 4.35n 0 4.351n 1.2 4.6n 1.2 4.601n 0 5.35n 0 5.351n 1.2 5.6n 1.2 5.601n 0 6.35n 0 6.351n 1.2 6.6n 1.2 6.601n 0 7.35n 0 7.351n 1.2 7.6n 1.2 7.601n 0 8.35n 0 8.351n 1.2 8.6n 1.2 8.601n 0 9.35n 0 9.351n 1.2 9.6n 1.2 9.601n 0 10.35n 0 10.351n 1.2 10.6n 1.2 10.601n 0 11.35n 0 11.351n 1.2 11.6n 1.2 11.601n 0 12.35n 0 12.351n 1.2 12.6n 1.2 12.601n 0 13.35n 0 13.351n 1.2 13.6n 1.2 13.601n 0 14.35n 0 14.351n 1.2 14.6n 1.2 14.601n 0 15.35n 0 15.351n 1.2 15.6n 1.2 15.601n 0 16.35n 0 16.351n 1.2 16.6n 1.2 16.601n 0 17.35n 0 17.351n 1.2 17.6n 1.2 17.601n 0 18.35n 0 18.351n 1.2 18.6n 1.2 18.601n 0 19.35n 0 19.351n 1.2 19.6n 1.2 19.601n 0 20.35n 0 20.351n 1.2 20.6n 1.2 20.601n 0 21.35n 0 21.351n 1.2 21.6n 1.2 21.601n 0 22.35n 0 22.351n 1.2 22.6n 1.2 22.601n 0 23.35n 0 23.351n 1.2 23.6n 1.2 23.601n 0 24.35n 0 24.351n 1.2 24.6n 1.2 24.601n 0 25.35n 0 25.351n 1.2 25.6n 1.2 25.601n 0 26.35n 0 26.351n 1.2 26.6n 1.2 26.601n 0 27.35n 0 27.351n 1.2 27.6n 1.2 27.601n 0 28.35n 0 28.351n 1.2 28.6n 1.2 28.601n 0 29.35n 0 29.351n 1.2 29.6n 1.2 29.601n 0 30.35n 0 30.351n 1.2 30.6n 1.2 30.601n 0 31.35n 0 31.351n 1.2 31.6n 1.2 31.601n 0 32.35n 0 32.351n 1.2 32.6n 1.2 32.601n 0 33.35n 0 33.351n 1.2 33.6n 1.2 33.601n 0 34.35n 0 34.351n 1.2 34.6n 1.2 34.601n 0 35.35n 0 35.351n 1.2 35.6n 1.2 35.601n 0 36.35n 0 36.351n 1.2 36.6n 1.2 36.601n 0 37.35n 0 37.351n 1.2 37.6n 1.2 37.601n 0 38.35n 0 38.351n 1.2 38.6n 1.2 38.601n 0 39.35n 0 39.351n 1.2 39.6n 1.2 39.601n 0 40.35n 0 40.351n 1.2 40.6n 1.2 40.601n 0 41.35n 0 41.351n 1.2 41.6n 1.2 41.601n 0 42.35n 0 42.351n 1.2 42.6n 1.2 42.601n 0 43.35n 0 43.351n 1.2 43.6n 1.2 43.601n 0 44.35n 0 44.351n 1.2 44.6n 1.2 44.601n 0 45.35n 0 45.351n 1.2 45.6n 1.2 45.601n 0 46.35n 0 46.351n 1.2 46.6n 1.2 46.601n 0 47.35n 0 47.351n 1.2 47.6n 1.2 47.601n 0 48.35n 0 48.351n 1.2 48.6n 1.2 48.601n 0 49.35n 0 49.351n 1.2 49.6n 1.2 49.601n 0 50.35n 0 50.351n 1.2 50.6n 1.2 50.601n 0 51.35n 0 51.351n 1.2 51.6n 1.2 51.601n 0 52.35n 0 52.351n 1.2 52.6n 1.2 52.601n 0 53.35n 0 53.351n 1.2 53.6n 1.2 53.601n 0 54.35n 0 54.351n 1.2 54.6n 1.2 54.601n 0 55.35n 0 55.351n 1.2 55.6n 1.2 55.601n 0 56.35n 0 56.351n 1.2 56.6n 1.2 56.601n 0 57.35n 0 57.351n 1.2 57.6n 1.2 57.601n 0 58.35n 0 58.351n 1.2 58.6n 1.2 58.601n 0 59.35n 0 59.351n 1.2 59.6n 1.2 59.601n 0 60.35n 0 60.351n 1.2 60.6n 1.2 60.601n 0 61.35n 0 61.351n 1.2 61.6n 1.2 61.601n 0 62.35n 0 62.351n 1.2 62.6n 1.2 62.601n 0 63.35n 0 63.351n 1.2 63.6n 1.2 63.601n 0 64.35n 0 64.351n 1.2 64.6n 1.2 64.601n 0 65.35n 0 65.351n 1.2 65.6n 1.2 65.601n 0 66.35n 0 66.351n 1.2 66.6n 1.2 66.601n 0 67.35n 0 67.351n 1.2 67.6n 1.2 67.601n 0 68.35n 0 68.351n 1.2 68.6n 1.2 68.601n 0 69.35n 0 69.351n 1.2 69.6n 1.2 69.601n 0 70.35n 0 70.351n 1.2 70.6n 1.2 70.601n 0 71.35n 0 71.351n 1.2 71.6n 1.2 71.601n 0 72.35n 0 72.351n 1.2 72.6n 1.2 72.601n 0 73.35n 0 73.351n 1.2 73.6n 1.2 73.601n 0 74.35n 0 74.351n 1.2 74.6n 1.2 74.601n 0 75.35n 0 75.351n 1.2 75.6n 1.2 75.601n 0 76.35n 0 76.351n 1.2 76.6n 1.2 76.601n 0 77.35n 0 77.351n 1.2 77.6n 1.2 77.601n 0 78.35n 0 78.351n 1.2 78.6n 1.2 78.601n 0 79.35n 0 79.351n 1.2 79.6n 1.2 79.601n 0 80.35n 0 80.351n 1.2 80.6n 1.2 80.601n 0 81.35n 0 81.351n 1.2 81.6n 1.2 81.601n 0 82.35n 0 82.351n 1.2 82.6n 1.2 82.601n 0 83.35n 0 83.351n 1.2 83.6n 1.2 83.601n 0 84.35n 0 84.351n 1.2 84.6n 1.2 84.601n 0 85.35n 0 85.351n 1.2 85.6n 1.2 85.601n 0 86.35n 0 86.351n 1.2 86.6n 1.2 86.601n 0 87.35n 0 87.351n 1.2 87.6n 1.2 87.601n 0 88.35n 0 88.351n 1.2 88.6n 1.2 88.601n 0 89.35n 0 89.351n 1.2 89.6n 1.2 89.601n 0 90.35n 0 90.351n 1.2 90.6n 1.2 90.601n 0 91.35n 0 91.351n 1.2 91.6n 1.2 91.601n 0 92.35n 0 92.351n 1.2 92.6n 1.2 92.601n 0 93.35n 0 93.351n 1.2 93.6n 1.2 93.601n 0 94.35n 0 94.351n 1.2 94.6n 1.2 94.601n 0 95.35n 0 95.351n 1.2 95.6n 1.2 95.601n 0 96.35n 0 96.351n 1.2 96.6n 1.2 96.601n 0 97.35n 0 97.351n 1.2 97.6n 1.2 97.601n 0 98.35n 0 98.351n 1.2 98.6n 1.2 98.601n 0 99.35n 0 99.351n 1.2 99.6n 1.2 99.601n 0 100.35n 0 100.351n 1.2 100.6n 1.2 100.601n 0 101.35n 0 101.351n 1.2 101.6n 1.2 101.601n 0 102.35n 0 102.351n 1.2 102.6n 1.2 102.601n 0 103.35n 0 103.351n 1.2 103.6n 1.2 103.601n 0 104.35n 0 104.351n 1.2 104.6n 1.2 104.601n 0 105.35n 0 105.351n 1.2 105.6n 1.2 105.601n 0 106.35n 0 106.351n 1.2 106.6n 1.2 106.601n 0 107.35n 0 107.351n 1.2 107.6n 1.2 107.601n 0 108.35n 0 108.351n 1.2 108.6n 1.2 108.601n 0 109.35n 0 109.351n 1.2 109.6n 1.2 109.601n 0 110.35n 0 110.351n 1.2 110.6n 1.2 110.601n 0 111.35n 0 111.351n 1.2 111.6n 1.2 111.601n 0 112.35n 0 112.351n 1.2 112.6n 1.2 112.601n 0 113.35n 0 113.351n 1.2 113.6n 1.2 113.601n 0 114.35n 0 114.351n 1.2 114.6n 1.2 114.601n 0 115.35n 0 115.351n 1.2 115.6n 1.2 115.601n 0 116.35n 0 116.351n 1.2 116.6n 1.2 116.601n 0 117.35n 0 117.351n 1.2 117.6n 1.2 117.601n 0 118.35n 0 118.351n 1.2 118.6n 1.2 118.601n 0 119.35n 0 119.351n 1.2 119.6n 1.2 119.601n 0 120.35n 0 120.351n 1.2 120.6n 1.2 120.601n 0 121.35n 0 121.351n 1.2 121.6n 1.2 121.601n 0 122.35n 0 122.351n 1.2 122.6n 1.2 122.601n 0 123.35n 0 123.351n 1.2 123.6n 1.2 123.601n 0 124.35n 0 124.351n 1.2 124.6n 1.2 124.601n 0 125.35n 0 125.351n 1.2 125.6n 1.2 125.601n 0 126.35n 0 126.351n 1.2 126.6n 1.2 126.601n 0 127.35n 0 127.351n 1.2 127.6n 1.2 127.601n 0 128.35n 0 128.351n 1.2 128.6n 1.2 128.601n 0 129.35n 0 129.351n 1.2 129.6n 1.2 129.601n 0 130.35n 0 130.351n 1.2 130.6n 1.2 130.601n 0 131.35n 0 131.351n 1.2 131.6n 1.2 131.601n 0 132.35n 0 132.351n 1.2 132.6n 1.2 132.601n 0 133.35n 0 133.351n 1.2 133.6n 1.2 133.601n 0 134.35n 0 134.351n 1.2 134.6n 1.2 134.601n 0 135.35n 0 135.351n 1.2 135.6n 1.2 135.601n 0 136.35n 0 136.351n 1.2 136.6n 1.2 136.601n 0 137.35n 0 137.351n 1.2 137.6n 1.2 137.601n 0 138.35n 0 138.351n 1.2 138.6n 1.2 138.601n 0 139.35n 0 139.351n 1.2 139.6n 1.2 139.601n 0 140.35n 0 140.351n 1.2 140.6n 1.2 140.601n 0 141.35n 0 141.351n 1.2 141.6n 1.2 141.601n 0 142.35n 0 142.351n 1.2 142.6n 1.2 142.601n 0 143.35n 0 143.351n 1.2 143.6n 1.2 143.601n 0 144.35n 0 144.351n 1.2 144.6n 1.2 144.601n 0 145.35n 0 145.351n 1.2 145.6n 1.2 145.601n 0 146.35n 0 146.351n 1.2 146.6n 1.2 146.601n 0 147.35n 0 147.351n 1.2 147.6n 1.2 147.601n 0 148.35n 0 148.351n 1.2 148.6n 1.2 148.601n 0 149.35n 0 149.351n 1.2 149.6n 1.2 149.601n 0 150.35n 0 150.351n 1.2 150.6n 1.2 150.601n 0 151.35n 0 151.351n 1.2 151.6n 1.2 151.601n 0 152.35n 0 152.351n 1.2 152.6n 1.2 152.601n 0 153.35n 0 153.351n 1.2 153.6n 1.2 153.601n 0 154.35n 0 154.351n 1.2 154.6n 1.2 154.601n 0 155.35n 0 155.351n 1.2 155.6n 1.2 155.601n 0 156.35n 0 156.351n 1.2 156.6n 1.2 156.601n 0 157.35n 0 157.351n 1.2 157.6n 1.2 157.601n 0 158.35n 0 158.351n 1.2 158.6n 1.2 158.601n 0 159.35n 0 159.351n 1.2 159.6n 1.2 159.601n 0 160.35n 0 160.351n 1.2 160.6n 1.2 160.601n 0 161.35n 0 161.351n 1.2 161.6n 1.2 161.601n 0 162.35n 0 162.351n 1.2 162.6n 1.2 162.601n 0 163.35n 0 163.351n 1.2 163.6n 1.2 163.601n 0 164.35n 0 164.351n 1.2 164.6n 1.2 164.601n 0 165.35n 0 165.351n 1.2 165.6n 1.2 165.601n 0 166.35n 0 166.351n 1.2 166.6n 1.2 166.601n 0 167.35n 0 167.351n 1.2 167.6n 1.2 167.601n 0 168.35n 0 168.351n 1.2 168.6n 1.2 168.601n 0 169.35n 0 169.351n 1.2 169.6n 1.2 169.601n 0 170.35n 0 170.351n 1.2 170.6n 1.2 170.601n 0 171.35n 0 171.351n 1.2 171.6n 1.2 171.601n 0 172.35n 0 172.351n 1.2 172.6n 1.2 172.601n 0 173.35n 0 173.351n 1.2 173.6n 1.2 173.601n 0 174.35n 0 174.351n 1.2 174.6n 1.2 174.601n 0 175.35n 0 175.351n 1.2 175.6n 1.2 175.601n 0 176.35n 0 176.351n 1.2 176.6n 1.2 176.601n 0 177.35n 0 177.351n 1.2 177.6n 1.2 177.601n 0 178.35n 0 178.351n 1.2 178.6n 1.2 178.601n 0 179.35n 0 179.351n 1.2 179.6n 1.2 179.601n 0 180.35n 0 180.351n 1.2 180.6n 1.2 180.601n 0 181.35n 0 181.351n 1.2 181.6n 1.2 181.601n 0 182.35n 0 182.351n 1.2 182.6n 1.2 182.601n 0 183.35n 0 183.351n 1.2 183.6n 1.2 183.601n 0 184.35n 0 184.351n 1.2 184.6n 1.2 184.601n 0 185.35n 0 185.351n 1.2 185.6n 1.2 185.601n 0 186.35n 0 186.351n 1.2 186.6n 1.2 186.601n 0 187.35n 0 187.351n 1.2 187.6n 1.2 187.601n 0 188.35n 0 188.351n 1.2 188.6n 1.2 188.601n 0 189.35n 0 189.351n 1.2 189.6n 1.2 189.601n 0 190.35n 0 190.351n 1.2 190.6n 1.2 190.601n 0 191.35n 0 191.351n 1.2 191.6n 1.2 191.601n 0 192.35n 0 192.351n 1.2 192.6n 1.2 192.601n 0 193.35n 0 193.351n 1.2 193.6n 1.2 193.601n 0 194.35n 0 194.351n 1.2 194.6n 1.2 194.601n 0 195.35n 0 195.351n 1.2 195.6n 1.2 195.601n 0 196.35n 0 196.351n 1.2 196.6n 1.2 196.601n 0 197.35n 0 197.351n 1.2 197.6n 1.2 197.601n 0 198.35n 0 198.351n 1.2 198.6n 1.2 198.601n 0 199.35n 0 199.351n 1.2 199.6n 1.2 199.601n 0 200.35n 0 200.351n 1.2 200.6n 1.2 200.601n 0 201.35n 0 201.351n 1.2 201.6n 1.2 201.601n 0 202.35n 0 202.351n 1.2 202.6n 1.2 202.601n 0 203.35n 0 203.351n 1.2 203.6n 1.2 203.601n 0 204.35n 0 204.351n 1.2 204.6n 1.2 204.601n 0 205.35n 0 205.351n 1.2 205.6n 1.2 205.601n 0 206.35n 0 206.351n 1.2 206.6n 1.2 206.601n 0 207.35n 0 207.351n 1.2 207.6n 1.2 207.601n 0 208.35n 0 208.351n 1.2 208.6n 1.2 208.601n 0 209.35n 0 209.351n 1.2 209.6n 1.2 209.601n 0 210.35n 0 210.351n 1.2 210.6n 1.2 210.601n 0 211.35n 0 211.351n 1.2 211.6n 1.2 211.601n 0 212.35n 0 212.351n 1.2 212.6n 1.2 212.601n 0 213.35n 0 213.351n 1.2 213.6n 1.2 213.601n 0 214.35n 0 214.351n 1.2 214.6n 1.2 214.601n 0 215.35n 0 215.351n 1.2 215.6n 1.2 215.601n 0 216.35n 0 216.351n 1.2 216.6n 1.2 216.601n 0 217.35n 0 217.351n 1.2 217.6n 1.2 217.601n 0 218.35n 0 218.351n 1.2 218.6n 1.2 218.601n 0 219.35n 0 219.351n 1.2 219.6n 1.2 219.601n 0 220.35n 0 220.351n 1.2 220.6n 1.2 220.601n 0 221.35n 0 221.351n 1.2 221.6n 1.2 221.601n 0 222.35n 0 222.351n 1.2 222.6n 1.2 222.601n 0 223.35n 0 223.351n 1.2 223.6n 1.2 223.601n 0 224.35n 0 224.351n 1.2 224.6n 1.2 224.601n 0 225.35n 0 225.351n 1.2 225.6n 1.2 225.601n 0 226.35n 0 226.351n 1.2 226.6n 1.2 226.601n 0 227.35n 0 227.351n 1.2 227.6n 1.2 227.601n 0 228.35n 0 228.351n 1.2 228.6n 1.2 228.601n 0 229.35n 0 229.351n 1.2 229.6n 1.2 229.601n 0 230.35n 0 230.351n 1.2 230.6n 1.2 230.601n 0 231.35n 0 231.351n 1.2 231.6n 1.2 231.601n 0 232.35n 0 232.351n 1.2 232.6n 1.2 232.601n 0 233.35n 0 233.351n 1.2 233.6n 1.2 233.601n 0 234.35n 0 234.351n 1.2 234.6n 1.2 234.601n 0 235.35n 0 235.351n 1.2 235.6n 1.2 235.601n 0 236.35n 0 236.351n 1.2 236.6n 1.2 236.601n 0 237.35n 0 237.351n 1.2 237.6n 1.2 237.601n 0 238.35n 0 238.351n 1.2 238.6n 1.2 238.601n 0 239.35n 0 239.351n 1.2 239.6n 1.2 239.601n 0 240.35n 0 240.351n 1.2 240.6n 1.2 240.601n 0 241.35n 0 241.351n 1.2 241.6n 1.2 241.601n 0 242.35n 0 242.351n 1.2 242.6n 1.2 242.601n 0 243.35n 0 243.351n 1.2 243.6n 1.2 243.601n 0 244.35n 0 244.351n 1.2 244.6n 1.2 244.601n 0 245.35n 0 245.351n 1.2 245.6n 1.2 245.601n 0 246.35n 0 246.351n 1.2 246.6n 1.2 246.601n 0 247.35n 0 247.351n 1.2 247.6n 1.2 247.601n 0 248.35n 0 248.351n 1.2 248.6n 1.2 248.601n 0 249.35n 0 249.351n 1.2 249.6n 1.2 249.601n 0 250.35n 0 250.351n 1.2 250.6n 1.2 250.601n 0 251.35n 0 251.351n 1.2 251.6n 1.2 251.601n 0 252.35n 0 252.351n 1.2 252.6n 1.2 252.601n 0 253.35n 0 253.351n 1.2 253.6n 1.2 253.601n 0 254.35n 0 254.351n 1.2 254.6n 1.2 254.601n 0 255.35n 0 255.351n 1.2 255.6n 1.2 255.601n 0 256.35n 0 256.351n 1.2 256.6n 1.2 256.601n 0 ]
Vvpre1 (Vpre1 0) vsource type=pwl wave=[0 0 1.3n 0 1.301n 1.2 1.6n 1.2 1.601n 0 2.3n 0 2.301n 1.2 2.6n 1.2 2.601n 0 3.3n 0 3.301n 1.2 3.6n 1.2 3.601n 0 4.3n 0 4.301n 1.2 4.6n 1.2 4.601n 0 5.3n 0 5.301n 1.2 5.6n 1.2 5.601n 0 6.3n 0 6.301n 1.2 6.6n 1.2 6.601n 0 7.3n 0 7.301n 1.2 7.6n 1.2 7.601n 0 8.3n 0 8.301n 1.2 8.6n 1.2 8.601n 0 9.3n 0 9.301n 1.2 9.6n 1.2 9.601n 0 10.3n 0 10.301n 1.2 10.6n 1.2 10.601n 0 11.3n 0 11.301n 1.2 11.6n 1.2 11.601n 0 12.3n 0 12.301n 1.2 12.6n 1.2 12.601n 0 13.3n 0 13.301n 1.2 13.6n 1.2 13.601n 0 14.3n 0 14.301n 1.2 14.6n 1.2 14.601n 0 15.3n 0 15.301n 1.2 15.6n 1.2 15.601n 0 16.3n 0 16.301n 1.2 16.6n 1.2 16.601n 0 17.3n 0 17.301n 1.2 17.6n 1.2 17.601n 0 18.3n 0 18.301n 1.2 18.6n 1.2 18.601n 0 19.3n 0 19.301n 1.2 19.6n 1.2 19.601n 0 20.3n 0 20.301n 1.2 20.6n 1.2 20.601n 0 21.3n 0 21.301n 1.2 21.6n 1.2 21.601n 0 22.3n 0 22.301n 1.2 22.6n 1.2 22.601n 0 23.3n 0 23.301n 1.2 23.6n 1.2 23.601n 0 24.3n 0 24.301n 1.2 24.6n 1.2 24.601n 0 25.3n 0 25.301n 1.2 25.6n 1.2 25.601n 0 26.3n 0 26.301n 1.2 26.6n 1.2 26.601n 0 27.3n 0 27.301n 1.2 27.6n 1.2 27.601n 0 28.3n 0 28.301n 1.2 28.6n 1.2 28.601n 0 29.3n 0 29.301n 1.2 29.6n 1.2 29.601n 0 30.3n 0 30.301n 1.2 30.6n 1.2 30.601n 0 31.3n 0 31.301n 1.2 31.6n 1.2 31.601n 0 32.3n 0 32.301n 1.2 32.6n 1.2 32.601n 0 33.3n 0 33.301n 1.2 33.6n 1.2 33.601n 0 34.3n 0 34.301n 1.2 34.6n 1.2 34.601n 0 35.3n 0 35.301n 1.2 35.6n 1.2 35.601n 0 36.3n 0 36.301n 1.2 36.6n 1.2 36.601n 0 37.3n 0 37.301n 1.2 37.6n 1.2 37.601n 0 38.3n 0 38.301n 1.2 38.6n 1.2 38.601n 0 39.3n 0 39.301n 1.2 39.6n 1.2 39.601n 0 40.3n 0 40.301n 1.2 40.6n 1.2 40.601n 0 41.3n 0 41.301n 1.2 41.6n 1.2 41.601n 0 42.3n 0 42.301n 1.2 42.6n 1.2 42.601n 0 43.3n 0 43.301n 1.2 43.6n 1.2 43.601n 0 44.3n 0 44.301n 1.2 44.6n 1.2 44.601n 0 45.3n 0 45.301n 1.2 45.6n 1.2 45.601n 0 46.3n 0 46.301n 1.2 46.6n 1.2 46.601n 0 47.3n 0 47.301n 1.2 47.6n 1.2 47.601n 0 48.3n 0 48.301n 1.2 48.6n 1.2 48.601n 0 49.3n 0 49.301n 1.2 49.6n 1.2 49.601n 0 50.3n 0 50.301n 1.2 50.6n 1.2 50.601n 0 51.3n 0 51.301n 1.2 51.6n 1.2 51.601n 0 52.3n 0 52.301n 1.2 52.6n 1.2 52.601n 0 53.3n 0 53.301n 1.2 53.6n 1.2 53.601n 0 54.3n 0 54.301n 1.2 54.6n 1.2 54.601n 0 55.3n 0 55.301n 1.2 55.6n 1.2 55.601n 0 56.3n 0 56.301n 1.2 56.6n 1.2 56.601n 0 57.3n 0 57.301n 1.2 57.6n 1.2 57.601n 0 58.3n 0 58.301n 1.2 58.6n 1.2 58.601n 0 59.3n 0 59.301n 1.2 59.6n 1.2 59.601n 0 60.3n 0 60.301n 1.2 60.6n 1.2 60.601n 0 61.3n 0 61.301n 1.2 61.6n 1.2 61.601n 0 62.3n 0 62.301n 1.2 62.6n 1.2 62.601n 0 63.3n 0 63.301n 1.2 63.6n 1.2 63.601n 0 64.3n 0 64.301n 1.2 64.6n 1.2 64.601n 0 65.3n 0 65.301n 1.2 65.6n 1.2 65.601n 0 66.3n 0 66.301n 1.2 66.6n 1.2 66.601n 0 67.3n 0 67.301n 1.2 67.6n 1.2 67.601n 0 68.3n 0 68.301n 1.2 68.6n 1.2 68.601n 0 69.3n 0 69.301n 1.2 69.6n 1.2 69.601n 0 70.3n 0 70.301n 1.2 70.6n 1.2 70.601n 0 71.3n 0 71.301n 1.2 71.6n 1.2 71.601n 0 72.3n 0 72.301n 1.2 72.6n 1.2 72.601n 0 73.3n 0 73.301n 1.2 73.6n 1.2 73.601n 0 74.3n 0 74.301n 1.2 74.6n 1.2 74.601n 0 75.3n 0 75.301n 1.2 75.6n 1.2 75.601n 0 76.3n 0 76.301n 1.2 76.6n 1.2 76.601n 0 77.3n 0 77.301n 1.2 77.6n 1.2 77.601n 0 78.3n 0 78.301n 1.2 78.6n 1.2 78.601n 0 79.3n 0 79.301n 1.2 79.6n 1.2 79.601n 0 80.3n 0 80.301n 1.2 80.6n 1.2 80.601n 0 81.3n 0 81.301n 1.2 81.6n 1.2 81.601n 0 82.3n 0 82.301n 1.2 82.6n 1.2 82.601n 0 83.3n 0 83.301n 1.2 83.6n 1.2 83.601n 0 84.3n 0 84.301n 1.2 84.6n 1.2 84.601n 0 85.3n 0 85.301n 1.2 85.6n 1.2 85.601n 0 86.3n 0 86.301n 1.2 86.6n 1.2 86.601n 0 87.3n 0 87.301n 1.2 87.6n 1.2 87.601n 0 88.3n 0 88.301n 1.2 88.6n 1.2 88.601n 0 89.3n 0 89.301n 1.2 89.6n 1.2 89.601n 0 90.3n 0 90.301n 1.2 90.6n 1.2 90.601n 0 91.3n 0 91.301n 1.2 91.6n 1.2 91.601n 0 92.3n 0 92.301n 1.2 92.6n 1.2 92.601n 0 93.3n 0 93.301n 1.2 93.6n 1.2 93.601n 0 94.3n 0 94.301n 1.2 94.6n 1.2 94.601n 0 95.3n 0 95.301n 1.2 95.6n 1.2 95.601n 0 96.3n 0 96.301n 1.2 96.6n 1.2 96.601n 0 97.3n 0 97.301n 1.2 97.6n 1.2 97.601n 0 98.3n 0 98.301n 1.2 98.6n 1.2 98.601n 0 99.3n 0 99.301n 1.2 99.6n 1.2 99.601n 0 100.3n 0 100.301n 1.2 100.6n 1.2 100.601n 0 101.3n 0 101.301n 1.2 101.6n 1.2 101.601n 0 102.3n 0 102.301n 1.2 102.6n 1.2 102.601n 0 103.3n 0 103.301n 1.2 103.6n 1.2 103.601n 0 104.3n 0 104.301n 1.2 104.6n 1.2 104.601n 0 105.3n 0 105.301n 1.2 105.6n 1.2 105.601n 0 106.3n 0 106.301n 1.2 106.6n 1.2 106.601n 0 107.3n 0 107.301n 1.2 107.6n 1.2 107.601n 0 108.3n 0 108.301n 1.2 108.6n 1.2 108.601n 0 109.3n 0 109.301n 1.2 109.6n 1.2 109.601n 0 110.3n 0 110.301n 1.2 110.6n 1.2 110.601n 0 111.3n 0 111.301n 1.2 111.6n 1.2 111.601n 0 112.3n 0 112.301n 1.2 112.6n 1.2 112.601n 0 113.3n 0 113.301n 1.2 113.6n 1.2 113.601n 0 114.3n 0 114.301n 1.2 114.6n 1.2 114.601n 0 115.3n 0 115.301n 1.2 115.6n 1.2 115.601n 0 116.3n 0 116.301n 1.2 116.6n 1.2 116.601n 0 117.3n 0 117.301n 1.2 117.6n 1.2 117.601n 0 118.3n 0 118.301n 1.2 118.6n 1.2 118.601n 0 119.3n 0 119.301n 1.2 119.6n 1.2 119.601n 0 120.3n 0 120.301n 1.2 120.6n 1.2 120.601n 0 121.3n 0 121.301n 1.2 121.6n 1.2 121.601n 0 122.3n 0 122.301n 1.2 122.6n 1.2 122.601n 0 123.3n 0 123.301n 1.2 123.6n 1.2 123.601n 0 124.3n 0 124.301n 1.2 124.6n 1.2 124.601n 0 125.3n 0 125.301n 1.2 125.6n 1.2 125.601n 0 126.3n 0 126.301n 1.2 126.6n 1.2 126.601n 0 127.3n 0 127.301n 1.2 127.6n 1.2 127.601n 0 128.3n 0 128.301n 1.2 128.6n 1.2 128.601n 0 129.3n 0 129.301n 1.2 129.6n 1.2 129.601n 0 130.3n 0 130.301n 1.2 130.6n 1.2 130.601n 0 131.3n 0 131.301n 1.2 131.6n 1.2 131.601n 0 132.3n 0 132.301n 1.2 132.6n 1.2 132.601n 0 133.3n 0 133.301n 1.2 133.6n 1.2 133.601n 0 134.3n 0 134.301n 1.2 134.6n 1.2 134.601n 0 135.3n 0 135.301n 1.2 135.6n 1.2 135.601n 0 136.3n 0 136.301n 1.2 136.6n 1.2 136.601n 0 137.3n 0 137.301n 1.2 137.6n 1.2 137.601n 0 138.3n 0 138.301n 1.2 138.6n 1.2 138.601n 0 139.3n 0 139.301n 1.2 139.6n 1.2 139.601n 0 140.3n 0 140.301n 1.2 140.6n 1.2 140.601n 0 141.3n 0 141.301n 1.2 141.6n 1.2 141.601n 0 142.3n 0 142.301n 1.2 142.6n 1.2 142.601n 0 143.3n 0 143.301n 1.2 143.6n 1.2 143.601n 0 144.3n 0 144.301n 1.2 144.6n 1.2 144.601n 0 145.3n 0 145.301n 1.2 145.6n 1.2 145.601n 0 146.3n 0 146.301n 1.2 146.6n 1.2 146.601n 0 147.3n 0 147.301n 1.2 147.6n 1.2 147.601n 0 148.3n 0 148.301n 1.2 148.6n 1.2 148.601n 0 149.3n 0 149.301n 1.2 149.6n 1.2 149.601n 0 150.3n 0 150.301n 1.2 150.6n 1.2 150.601n 0 151.3n 0 151.301n 1.2 151.6n 1.2 151.601n 0 152.3n 0 152.301n 1.2 152.6n 1.2 152.601n 0 153.3n 0 153.301n 1.2 153.6n 1.2 153.601n 0 154.3n 0 154.301n 1.2 154.6n 1.2 154.601n 0 155.3n 0 155.301n 1.2 155.6n 1.2 155.601n 0 156.3n 0 156.301n 1.2 156.6n 1.2 156.601n 0 157.3n 0 157.301n 1.2 157.6n 1.2 157.601n 0 158.3n 0 158.301n 1.2 158.6n 1.2 158.601n 0 159.3n 0 159.301n 1.2 159.6n 1.2 159.601n 0 160.3n 0 160.301n 1.2 160.6n 1.2 160.601n 0 161.3n 0 161.301n 1.2 161.6n 1.2 161.601n 0 162.3n 0 162.301n 1.2 162.6n 1.2 162.601n 0 163.3n 0 163.301n 1.2 163.6n 1.2 163.601n 0 164.3n 0 164.301n 1.2 164.6n 1.2 164.601n 0 165.3n 0 165.301n 1.2 165.6n 1.2 165.601n 0 166.3n 0 166.301n 1.2 166.6n 1.2 166.601n 0 167.3n 0 167.301n 1.2 167.6n 1.2 167.601n 0 168.3n 0 168.301n 1.2 168.6n 1.2 168.601n 0 169.3n 0 169.301n 1.2 169.6n 1.2 169.601n 0 170.3n 0 170.301n 1.2 170.6n 1.2 170.601n 0 171.3n 0 171.301n 1.2 171.6n 1.2 171.601n 0 172.3n 0 172.301n 1.2 172.6n 1.2 172.601n 0 173.3n 0 173.301n 1.2 173.6n 1.2 173.601n 0 174.3n 0 174.301n 1.2 174.6n 1.2 174.601n 0 175.3n 0 175.301n 1.2 175.6n 1.2 175.601n 0 176.3n 0 176.301n 1.2 176.6n 1.2 176.601n 0 177.3n 0 177.301n 1.2 177.6n 1.2 177.601n 0 178.3n 0 178.301n 1.2 178.6n 1.2 178.601n 0 179.3n 0 179.301n 1.2 179.6n 1.2 179.601n 0 180.3n 0 180.301n 1.2 180.6n 1.2 180.601n 0 181.3n 0 181.301n 1.2 181.6n 1.2 181.601n 0 182.3n 0 182.301n 1.2 182.6n 1.2 182.601n 0 183.3n 0 183.301n 1.2 183.6n 1.2 183.601n 0 184.3n 0 184.301n 1.2 184.6n 1.2 184.601n 0 185.3n 0 185.301n 1.2 185.6n 1.2 185.601n 0 186.3n 0 186.301n 1.2 186.6n 1.2 186.601n 0 187.3n 0 187.301n 1.2 187.6n 1.2 187.601n 0 188.3n 0 188.301n 1.2 188.6n 1.2 188.601n 0 189.3n 0 189.301n 1.2 189.6n 1.2 189.601n 0 190.3n 0 190.301n 1.2 190.6n 1.2 190.601n 0 191.3n 0 191.301n 1.2 191.6n 1.2 191.601n 0 192.3n 0 192.301n 1.2 192.6n 1.2 192.601n 0 193.3n 0 193.301n 1.2 193.6n 1.2 193.601n 0 194.3n 0 194.301n 1.2 194.6n 1.2 194.601n 0 195.3n 0 195.301n 1.2 195.6n 1.2 195.601n 0 196.3n 0 196.301n 1.2 196.6n 1.2 196.601n 0 197.3n 0 197.301n 1.2 197.6n 1.2 197.601n 0 198.3n 0 198.301n 1.2 198.6n 1.2 198.601n 0 199.3n 0 199.301n 1.2 199.6n 1.2 199.601n 0 200.3n 0 200.301n 1.2 200.6n 1.2 200.601n 0 201.3n 0 201.301n 1.2 201.6n 1.2 201.601n 0 202.3n 0 202.301n 1.2 202.6n 1.2 202.601n 0 203.3n 0 203.301n 1.2 203.6n 1.2 203.601n 0 204.3n 0 204.301n 1.2 204.6n 1.2 204.601n 0 205.3n 0 205.301n 1.2 205.6n 1.2 205.601n 0 206.3n 0 206.301n 1.2 206.6n 1.2 206.601n 0 207.3n 0 207.301n 1.2 207.6n 1.2 207.601n 0 208.3n 0 208.301n 1.2 208.6n 1.2 208.601n 0 209.3n 0 209.301n 1.2 209.6n 1.2 209.601n 0 210.3n 0 210.301n 1.2 210.6n 1.2 210.601n 0 211.3n 0 211.301n 1.2 211.6n 1.2 211.601n 0 212.3n 0 212.301n 1.2 212.6n 1.2 212.601n 0 213.3n 0 213.301n 1.2 213.6n 1.2 213.601n 0 214.3n 0 214.301n 1.2 214.6n 1.2 214.601n 0 215.3n 0 215.301n 1.2 215.6n 1.2 215.601n 0 216.3n 0 216.301n 1.2 216.6n 1.2 216.601n 0 217.3n 0 217.301n 1.2 217.6n 1.2 217.601n 0 218.3n 0 218.301n 1.2 218.6n 1.2 218.601n 0 219.3n 0 219.301n 1.2 219.6n 1.2 219.601n 0 220.3n 0 220.301n 1.2 220.6n 1.2 220.601n 0 221.3n 0 221.301n 1.2 221.6n 1.2 221.601n 0 222.3n 0 222.301n 1.2 222.6n 1.2 222.601n 0 223.3n 0 223.301n 1.2 223.6n 1.2 223.601n 0 224.3n 0 224.301n 1.2 224.6n 1.2 224.601n 0 225.3n 0 225.301n 1.2 225.6n 1.2 225.601n 0 226.3n 0 226.301n 1.2 226.6n 1.2 226.601n 0 227.3n 0 227.301n 1.2 227.6n 1.2 227.601n 0 228.3n 0 228.301n 1.2 228.6n 1.2 228.601n 0 229.3n 0 229.301n 1.2 229.6n 1.2 229.601n 0 230.3n 0 230.301n 1.2 230.6n 1.2 230.601n 0 231.3n 0 231.301n 1.2 231.6n 1.2 231.601n 0 232.3n 0 232.301n 1.2 232.6n 1.2 232.601n 0 233.3n 0 233.301n 1.2 233.6n 1.2 233.601n 0 234.3n 0 234.301n 1.2 234.6n 1.2 234.601n 0 235.3n 0 235.301n 1.2 235.6n 1.2 235.601n 0 236.3n 0 236.301n 1.2 236.6n 1.2 236.601n 0 237.3n 0 237.301n 1.2 237.6n 1.2 237.601n 0 238.3n 0 238.301n 1.2 238.6n 1.2 238.601n 0 239.3n 0 239.301n 1.2 239.6n 1.2 239.601n 0 240.3n 0 240.301n 1.2 240.6n 1.2 240.601n 0 241.3n 0 241.301n 1.2 241.6n 1.2 241.601n 0 242.3n 0 242.301n 1.2 242.6n 1.2 242.601n 0 243.3n 0 243.301n 1.2 243.6n 1.2 243.601n 0 244.3n 0 244.301n 1.2 244.6n 1.2 244.601n 0 245.3n 0 245.301n 1.2 245.6n 1.2 245.601n 0 246.3n 0 246.301n 1.2 246.6n 1.2 246.601n 0 247.3n 0 247.301n 1.2 247.6n 1.2 247.601n 0 248.3n 0 248.301n 1.2 248.6n 1.2 248.601n 0 249.3n 0 249.301n 1.2 249.6n 1.2 249.601n 0 250.3n 0 250.301n 1.2 250.6n 1.2 250.601n 0 251.3n 0 251.301n 1.2 251.6n 1.2 251.601n 0 252.3n 0 252.301n 1.2 252.6n 1.2 252.601n 0 253.3n 0 253.301n 1.2 253.6n 1.2 253.601n 0 254.3n 0 254.301n 1.2 254.6n 1.2 254.601n 0 255.3n 0 255.301n 1.2 255.6n 1.2 255.601n 0 256.3n 0 256.301n 1.2 256.6n 1.2 256.601n 0 ]
Vvpre2 (Vpre2 0) vsource type=pwl wave=[0 0 1.2n 0 1.201n 1.2 1.6n 1.2 1.601n 0 2.2n 0 2.201n 1.2 2.6n 1.2 2.601n 0 3.2n 0 3.201n 1.2 3.6n 1.2 3.601n 0 4.2n 0 4.201n 1.2 4.6n 1.2 4.601n 0 5.2n 0 5.201n 1.2 5.6n 1.2 5.601n 0 6.2n 0 6.201n 1.2 6.6n 1.2 6.601n 0 7.2n 0 7.201n 1.2 7.6n 1.2 7.601n 0 8.2n 0 8.201n 1.2 8.6n 1.2 8.601n 0 9.2n 0 9.201n 1.2 9.6n 1.2 9.601n 0 10.2n 0 10.201n 1.2 10.6n 1.2 10.601n 0 11.2n 0 11.201n 1.2 11.6n 1.2 11.601n 0 12.2n 0 12.201n 1.2 12.6n 1.2 12.601n 0 13.2n 0 13.201n 1.2 13.6n 1.2 13.601n 0 14.2n 0 14.201n 1.2 14.6n 1.2 14.601n 0 15.2n 0 15.201n 1.2 15.6n 1.2 15.601n 0 16.2n 0 16.201n 1.2 16.6n 1.2 16.601n 0 17.2n 0 17.201n 1.2 17.6n 1.2 17.601n 0 18.2n 0 18.201n 1.2 18.6n 1.2 18.601n 0 19.2n 0 19.201n 1.2 19.6n 1.2 19.601n 0 20.2n 0 20.201n 1.2 20.6n 1.2 20.601n 0 21.2n 0 21.201n 1.2 21.6n 1.2 21.601n 0 22.2n 0 22.201n 1.2 22.6n 1.2 22.601n 0 23.2n 0 23.201n 1.2 23.6n 1.2 23.601n 0 24.2n 0 24.201n 1.2 24.6n 1.2 24.601n 0 25.2n 0 25.201n 1.2 25.6n 1.2 25.601n 0 26.2n 0 26.201n 1.2 26.6n 1.2 26.601n 0 27.2n 0 27.201n 1.2 27.6n 1.2 27.601n 0 28.2n 0 28.201n 1.2 28.6n 1.2 28.601n 0 29.2n 0 29.201n 1.2 29.6n 1.2 29.601n 0 30.2n 0 30.201n 1.2 30.6n 1.2 30.601n 0 31.2n 0 31.201n 1.2 31.6n 1.2 31.601n 0 32.2n 0 32.201n 1.2 32.6n 1.2 32.601n 0 33.2n 0 33.201n 1.2 33.6n 1.2 33.601n 0 34.2n 0 34.201n 1.2 34.6n 1.2 34.601n 0 35.2n 0 35.201n 1.2 35.6n 1.2 35.601n 0 36.2n 0 36.201n 1.2 36.6n 1.2 36.601n 0 37.2n 0 37.201n 1.2 37.6n 1.2 37.601n 0 38.2n 0 38.201n 1.2 38.6n 1.2 38.601n 0 39.2n 0 39.201n 1.2 39.6n 1.2 39.601n 0 40.2n 0 40.201n 1.2 40.6n 1.2 40.601n 0 41.2n 0 41.201n 1.2 41.6n 1.2 41.601n 0 42.2n 0 42.201n 1.2 42.6n 1.2 42.601n 0 43.2n 0 43.201n 1.2 43.6n 1.2 43.601n 0 44.2n 0 44.201n 1.2 44.6n 1.2 44.601n 0 45.2n 0 45.201n 1.2 45.6n 1.2 45.601n 0 46.2n 0 46.201n 1.2 46.6n 1.2 46.601n 0 47.2n 0 47.201n 1.2 47.6n 1.2 47.601n 0 48.2n 0 48.201n 1.2 48.6n 1.2 48.601n 0 49.2n 0 49.201n 1.2 49.6n 1.2 49.601n 0 50.2n 0 50.201n 1.2 50.6n 1.2 50.601n 0 51.2n 0 51.201n 1.2 51.6n 1.2 51.601n 0 52.2n 0 52.201n 1.2 52.6n 1.2 52.601n 0 53.2n 0 53.201n 1.2 53.6n 1.2 53.601n 0 54.2n 0 54.201n 1.2 54.6n 1.2 54.601n 0 55.2n 0 55.201n 1.2 55.6n 1.2 55.601n 0 56.2n 0 56.201n 1.2 56.6n 1.2 56.601n 0 57.2n 0 57.201n 1.2 57.6n 1.2 57.601n 0 58.2n 0 58.201n 1.2 58.6n 1.2 58.601n 0 59.2n 0 59.201n 1.2 59.6n 1.2 59.601n 0 60.2n 0 60.201n 1.2 60.6n 1.2 60.601n 0 61.2n 0 61.201n 1.2 61.6n 1.2 61.601n 0 62.2n 0 62.201n 1.2 62.6n 1.2 62.601n 0 63.2n 0 63.201n 1.2 63.6n 1.2 63.601n 0 64.2n 0 64.201n 1.2 64.6n 1.2 64.601n 0 65.2n 0 65.201n 1.2 65.6n 1.2 65.601n 0 66.2n 0 66.201n 1.2 66.6n 1.2 66.601n 0 67.2n 0 67.201n 1.2 67.6n 1.2 67.601n 0 68.2n 0 68.201n 1.2 68.6n 1.2 68.601n 0 69.2n 0 69.201n 1.2 69.6n 1.2 69.601n 0 70.2n 0 70.201n 1.2 70.6n 1.2 70.601n 0 71.2n 0 71.201n 1.2 71.6n 1.2 71.601n 0 72.2n 0 72.201n 1.2 72.6n 1.2 72.601n 0 73.2n 0 73.201n 1.2 73.6n 1.2 73.601n 0 74.2n 0 74.201n 1.2 74.6n 1.2 74.601n 0 75.2n 0 75.201n 1.2 75.6n 1.2 75.601n 0 76.2n 0 76.201n 1.2 76.6n 1.2 76.601n 0 77.2n 0 77.201n 1.2 77.6n 1.2 77.601n 0 78.2n 0 78.201n 1.2 78.6n 1.2 78.601n 0 79.2n 0 79.201n 1.2 79.6n 1.2 79.601n 0 80.2n 0 80.201n 1.2 80.6n 1.2 80.601n 0 81.2n 0 81.201n 1.2 81.6n 1.2 81.601n 0 82.2n 0 82.201n 1.2 82.6n 1.2 82.601n 0 83.2n 0 83.201n 1.2 83.6n 1.2 83.601n 0 84.2n 0 84.201n 1.2 84.6n 1.2 84.601n 0 85.2n 0 85.201n 1.2 85.6n 1.2 85.601n 0 86.2n 0 86.201n 1.2 86.6n 1.2 86.601n 0 87.2n 0 87.201n 1.2 87.6n 1.2 87.601n 0 88.2n 0 88.201n 1.2 88.6n 1.2 88.601n 0 89.2n 0 89.201n 1.2 89.6n 1.2 89.601n 0 90.2n 0 90.201n 1.2 90.6n 1.2 90.601n 0 91.2n 0 91.201n 1.2 91.6n 1.2 91.601n 0 92.2n 0 92.201n 1.2 92.6n 1.2 92.601n 0 93.2n 0 93.201n 1.2 93.6n 1.2 93.601n 0 94.2n 0 94.201n 1.2 94.6n 1.2 94.601n 0 95.2n 0 95.201n 1.2 95.6n 1.2 95.601n 0 96.2n 0 96.201n 1.2 96.6n 1.2 96.601n 0 97.2n 0 97.201n 1.2 97.6n 1.2 97.601n 0 98.2n 0 98.201n 1.2 98.6n 1.2 98.601n 0 99.2n 0 99.201n 1.2 99.6n 1.2 99.601n 0 100.2n 0 100.201n 1.2 100.6n 1.2 100.601n 0 101.2n 0 101.201n 1.2 101.6n 1.2 101.601n 0 102.2n 0 102.201n 1.2 102.6n 1.2 102.601n 0 103.2n 0 103.201n 1.2 103.6n 1.2 103.601n 0 104.2n 0 104.201n 1.2 104.6n 1.2 104.601n 0 105.2n 0 105.201n 1.2 105.6n 1.2 105.601n 0 106.2n 0 106.201n 1.2 106.6n 1.2 106.601n 0 107.2n 0 107.201n 1.2 107.6n 1.2 107.601n 0 108.2n 0 108.201n 1.2 108.6n 1.2 108.601n 0 109.2n 0 109.201n 1.2 109.6n 1.2 109.601n 0 110.2n 0 110.201n 1.2 110.6n 1.2 110.601n 0 111.2n 0 111.201n 1.2 111.6n 1.2 111.601n 0 112.2n 0 112.201n 1.2 112.6n 1.2 112.601n 0 113.2n 0 113.201n 1.2 113.6n 1.2 113.601n 0 114.2n 0 114.201n 1.2 114.6n 1.2 114.601n 0 115.2n 0 115.201n 1.2 115.6n 1.2 115.601n 0 116.2n 0 116.201n 1.2 116.6n 1.2 116.601n 0 117.2n 0 117.201n 1.2 117.6n 1.2 117.601n 0 118.2n 0 118.201n 1.2 118.6n 1.2 118.601n 0 119.2n 0 119.201n 1.2 119.6n 1.2 119.601n 0 120.2n 0 120.201n 1.2 120.6n 1.2 120.601n 0 121.2n 0 121.201n 1.2 121.6n 1.2 121.601n 0 122.2n 0 122.201n 1.2 122.6n 1.2 122.601n 0 123.2n 0 123.201n 1.2 123.6n 1.2 123.601n 0 124.2n 0 124.201n 1.2 124.6n 1.2 124.601n 0 125.2n 0 125.201n 1.2 125.6n 1.2 125.601n 0 126.2n 0 126.201n 1.2 126.6n 1.2 126.601n 0 127.2n 0 127.201n 1.2 127.6n 1.2 127.601n 0 128.2n 0 128.201n 1.2 128.6n 1.2 128.601n 0 129.2n 0 129.201n 1.2 129.6n 1.2 129.601n 0 130.2n 0 130.201n 1.2 130.6n 1.2 130.601n 0 131.2n 0 131.201n 1.2 131.6n 1.2 131.601n 0 132.2n 0 132.201n 1.2 132.6n 1.2 132.601n 0 133.2n 0 133.201n 1.2 133.6n 1.2 133.601n 0 134.2n 0 134.201n 1.2 134.6n 1.2 134.601n 0 135.2n 0 135.201n 1.2 135.6n 1.2 135.601n 0 136.2n 0 136.201n 1.2 136.6n 1.2 136.601n 0 137.2n 0 137.201n 1.2 137.6n 1.2 137.601n 0 138.2n 0 138.201n 1.2 138.6n 1.2 138.601n 0 139.2n 0 139.201n 1.2 139.6n 1.2 139.601n 0 140.2n 0 140.201n 1.2 140.6n 1.2 140.601n 0 141.2n 0 141.201n 1.2 141.6n 1.2 141.601n 0 142.2n 0 142.201n 1.2 142.6n 1.2 142.601n 0 143.2n 0 143.201n 1.2 143.6n 1.2 143.601n 0 144.2n 0 144.201n 1.2 144.6n 1.2 144.601n 0 145.2n 0 145.201n 1.2 145.6n 1.2 145.601n 0 146.2n 0 146.201n 1.2 146.6n 1.2 146.601n 0 147.2n 0 147.201n 1.2 147.6n 1.2 147.601n 0 148.2n 0 148.201n 1.2 148.6n 1.2 148.601n 0 149.2n 0 149.201n 1.2 149.6n 1.2 149.601n 0 150.2n 0 150.201n 1.2 150.6n 1.2 150.601n 0 151.2n 0 151.201n 1.2 151.6n 1.2 151.601n 0 152.2n 0 152.201n 1.2 152.6n 1.2 152.601n 0 153.2n 0 153.201n 1.2 153.6n 1.2 153.601n 0 154.2n 0 154.201n 1.2 154.6n 1.2 154.601n 0 155.2n 0 155.201n 1.2 155.6n 1.2 155.601n 0 156.2n 0 156.201n 1.2 156.6n 1.2 156.601n 0 157.2n 0 157.201n 1.2 157.6n 1.2 157.601n 0 158.2n 0 158.201n 1.2 158.6n 1.2 158.601n 0 159.2n 0 159.201n 1.2 159.6n 1.2 159.601n 0 160.2n 0 160.201n 1.2 160.6n 1.2 160.601n 0 161.2n 0 161.201n 1.2 161.6n 1.2 161.601n 0 162.2n 0 162.201n 1.2 162.6n 1.2 162.601n 0 163.2n 0 163.201n 1.2 163.6n 1.2 163.601n 0 164.2n 0 164.201n 1.2 164.6n 1.2 164.601n 0 165.2n 0 165.201n 1.2 165.6n 1.2 165.601n 0 166.2n 0 166.201n 1.2 166.6n 1.2 166.601n 0 167.2n 0 167.201n 1.2 167.6n 1.2 167.601n 0 168.2n 0 168.201n 1.2 168.6n 1.2 168.601n 0 169.2n 0 169.201n 1.2 169.6n 1.2 169.601n 0 170.2n 0 170.201n 1.2 170.6n 1.2 170.601n 0 171.2n 0 171.201n 1.2 171.6n 1.2 171.601n 0 172.2n 0 172.201n 1.2 172.6n 1.2 172.601n 0 173.2n 0 173.201n 1.2 173.6n 1.2 173.601n 0 174.2n 0 174.201n 1.2 174.6n 1.2 174.601n 0 175.2n 0 175.201n 1.2 175.6n 1.2 175.601n 0 176.2n 0 176.201n 1.2 176.6n 1.2 176.601n 0 177.2n 0 177.201n 1.2 177.6n 1.2 177.601n 0 178.2n 0 178.201n 1.2 178.6n 1.2 178.601n 0 179.2n 0 179.201n 1.2 179.6n 1.2 179.601n 0 180.2n 0 180.201n 1.2 180.6n 1.2 180.601n 0 181.2n 0 181.201n 1.2 181.6n 1.2 181.601n 0 182.2n 0 182.201n 1.2 182.6n 1.2 182.601n 0 183.2n 0 183.201n 1.2 183.6n 1.2 183.601n 0 184.2n 0 184.201n 1.2 184.6n 1.2 184.601n 0 185.2n 0 185.201n 1.2 185.6n 1.2 185.601n 0 186.2n 0 186.201n 1.2 186.6n 1.2 186.601n 0 187.2n 0 187.201n 1.2 187.6n 1.2 187.601n 0 188.2n 0 188.201n 1.2 188.6n 1.2 188.601n 0 189.2n 0 189.201n 1.2 189.6n 1.2 189.601n 0 190.2n 0 190.201n 1.2 190.6n 1.2 190.601n 0 191.2n 0 191.201n 1.2 191.6n 1.2 191.601n 0 192.2n 0 192.201n 1.2 192.6n 1.2 192.601n 0 193.2n 0 193.201n 1.2 193.6n 1.2 193.601n 0 194.2n 0 194.201n 1.2 194.6n 1.2 194.601n 0 195.2n 0 195.201n 1.2 195.6n 1.2 195.601n 0 196.2n 0 196.201n 1.2 196.6n 1.2 196.601n 0 197.2n 0 197.201n 1.2 197.6n 1.2 197.601n 0 198.2n 0 198.201n 1.2 198.6n 1.2 198.601n 0 199.2n 0 199.201n 1.2 199.6n 1.2 199.601n 0 200.2n 0 200.201n 1.2 200.6n 1.2 200.601n 0 201.2n 0 201.201n 1.2 201.6n 1.2 201.601n 0 202.2n 0 202.201n 1.2 202.6n 1.2 202.601n 0 203.2n 0 203.201n 1.2 203.6n 1.2 203.601n 0 204.2n 0 204.201n 1.2 204.6n 1.2 204.601n 0 205.2n 0 205.201n 1.2 205.6n 1.2 205.601n 0 206.2n 0 206.201n 1.2 206.6n 1.2 206.601n 0 207.2n 0 207.201n 1.2 207.6n 1.2 207.601n 0 208.2n 0 208.201n 1.2 208.6n 1.2 208.601n 0 209.2n 0 209.201n 1.2 209.6n 1.2 209.601n 0 210.2n 0 210.201n 1.2 210.6n 1.2 210.601n 0 211.2n 0 211.201n 1.2 211.6n 1.2 211.601n 0 212.2n 0 212.201n 1.2 212.6n 1.2 212.601n 0 213.2n 0 213.201n 1.2 213.6n 1.2 213.601n 0 214.2n 0 214.201n 1.2 214.6n 1.2 214.601n 0 215.2n 0 215.201n 1.2 215.6n 1.2 215.601n 0 216.2n 0 216.201n 1.2 216.6n 1.2 216.601n 0 217.2n 0 217.201n 1.2 217.6n 1.2 217.601n 0 218.2n 0 218.201n 1.2 218.6n 1.2 218.601n 0 219.2n 0 219.201n 1.2 219.6n 1.2 219.601n 0 220.2n 0 220.201n 1.2 220.6n 1.2 220.601n 0 221.2n 0 221.201n 1.2 221.6n 1.2 221.601n 0 222.2n 0 222.201n 1.2 222.6n 1.2 222.601n 0 223.2n 0 223.201n 1.2 223.6n 1.2 223.601n 0 224.2n 0 224.201n 1.2 224.6n 1.2 224.601n 0 225.2n 0 225.201n 1.2 225.6n 1.2 225.601n 0 226.2n 0 226.201n 1.2 226.6n 1.2 226.601n 0 227.2n 0 227.201n 1.2 227.6n 1.2 227.601n 0 228.2n 0 228.201n 1.2 228.6n 1.2 228.601n 0 229.2n 0 229.201n 1.2 229.6n 1.2 229.601n 0 230.2n 0 230.201n 1.2 230.6n 1.2 230.601n 0 231.2n 0 231.201n 1.2 231.6n 1.2 231.601n 0 232.2n 0 232.201n 1.2 232.6n 1.2 232.601n 0 233.2n 0 233.201n 1.2 233.6n 1.2 233.601n 0 234.2n 0 234.201n 1.2 234.6n 1.2 234.601n 0 235.2n 0 235.201n 1.2 235.6n 1.2 235.601n 0 236.2n 0 236.201n 1.2 236.6n 1.2 236.601n 0 237.2n 0 237.201n 1.2 237.6n 1.2 237.601n 0 238.2n 0 238.201n 1.2 238.6n 1.2 238.601n 0 239.2n 0 239.201n 1.2 239.6n 1.2 239.601n 0 240.2n 0 240.201n 1.2 240.6n 1.2 240.601n 0 241.2n 0 241.201n 1.2 241.6n 1.2 241.601n 0 242.2n 0 242.201n 1.2 242.6n 1.2 242.601n 0 243.2n 0 243.201n 1.2 243.6n 1.2 243.601n 0 244.2n 0 244.201n 1.2 244.6n 1.2 244.601n 0 245.2n 0 245.201n 1.2 245.6n 1.2 245.601n 0 246.2n 0 246.201n 1.2 246.6n 1.2 246.601n 0 247.2n 0 247.201n 1.2 247.6n 1.2 247.601n 0 248.2n 0 248.201n 1.2 248.6n 1.2 248.601n 0 249.2n 0 249.201n 1.2 249.6n 1.2 249.601n 0 250.2n 0 250.201n 1.2 250.6n 1.2 250.601n 0 251.2n 0 251.201n 1.2 251.6n 1.2 251.601n 0 252.2n 0 252.201n 1.2 252.6n 1.2 252.601n 0 253.2n 0 253.201n 1.2 253.6n 1.2 253.601n 0 254.2n 0 254.201n 1.2 254.6n 1.2 254.601n 0 255.2n 0 255.201n 1.2 255.6n 1.2 255.601n 0 256.2n 0 256.201n 1.2 256.6n 1.2 256.601n 0 ]
Vvpre3 (Vpre3 0) vsource type=pwl wave=[0 0 1.0n 0 1.001n 1.2 1.6n 1.2 1.601n 0 2.0n 0 2.001n 1.2 2.6n 1.2 2.601n 0 3.0n 0 3.001n 1.2 3.6n 1.2 3.601n 0 4.0n 0 4.001n 1.2 4.6n 1.2 4.601n 0 5.0n 0 5.001n 1.2 5.6n 1.2 5.601n 0 6.0n 0 6.001n 1.2 6.6n 1.2 6.601n 0 7.0n 0 7.001n 1.2 7.6n 1.2 7.601n 0 8.0n 0 8.001n 1.2 8.6n 1.2 8.601n 0 9.0n 0 9.001n 1.2 9.6n 1.2 9.601n 0 10.0n 0 10.001n 1.2 10.6n 1.2 10.601n 0 11.0n 0 11.001n 1.2 11.6n 1.2 11.601n 0 12.0n 0 12.001n 1.2 12.6n 1.2 12.601n 0 13.0n 0 13.001n 1.2 13.6n 1.2 13.601n 0 14.0n 0 14.001n 1.2 14.6n 1.2 14.601n 0 15.0n 0 15.001n 1.2 15.6n 1.2 15.601n 0 16.0n 0 16.001n 1.2 16.6n 1.2 16.601n 0 17.0n 0 17.001n 1.2 17.6n 1.2 17.601n 0 18.0n 0 18.001n 1.2 18.6n 1.2 18.601n 0 19.0n 0 19.001n 1.2 19.6n 1.2 19.601n 0 20.0n 0 20.001n 1.2 20.6n 1.2 20.601n 0 21.0n 0 21.001n 1.2 21.6n 1.2 21.601n 0 22.0n 0 22.001n 1.2 22.6n 1.2 22.601n 0 23.0n 0 23.001n 1.2 23.6n 1.2 23.601n 0 24.0n 0 24.001n 1.2 24.6n 1.2 24.601n 0 25.0n 0 25.001n 1.2 25.6n 1.2 25.601n 0 26.0n 0 26.001n 1.2 26.6n 1.2 26.601n 0 27.0n 0 27.001n 1.2 27.6n 1.2 27.601n 0 28.0n 0 28.001n 1.2 28.6n 1.2 28.601n 0 29.0n 0 29.001n 1.2 29.6n 1.2 29.601n 0 30.0n 0 30.001n 1.2 30.6n 1.2 30.601n 0 31.0n 0 31.001n 1.2 31.6n 1.2 31.601n 0 32.0n 0 32.001n 1.2 32.6n 1.2 32.601n 0 33.0n 0 33.001n 1.2 33.6n 1.2 33.601n 0 34.0n 0 34.001n 1.2 34.6n 1.2 34.601n 0 35.0n 0 35.001n 1.2 35.6n 1.2 35.601n 0 36.0n 0 36.001n 1.2 36.6n 1.2 36.601n 0 37.0n 0 37.001n 1.2 37.6n 1.2 37.601n 0 38.0n 0 38.001n 1.2 38.6n 1.2 38.601n 0 39.0n 0 39.001n 1.2 39.6n 1.2 39.601n 0 40.0n 0 40.001n 1.2 40.6n 1.2 40.601n 0 41.0n 0 41.001n 1.2 41.6n 1.2 41.601n 0 42.0n 0 42.001n 1.2 42.6n 1.2 42.601n 0 43.0n 0 43.001n 1.2 43.6n 1.2 43.601n 0 44.0n 0 44.001n 1.2 44.6n 1.2 44.601n 0 45.0n 0 45.001n 1.2 45.6n 1.2 45.601n 0 46.0n 0 46.001n 1.2 46.6n 1.2 46.601n 0 47.0n 0 47.001n 1.2 47.6n 1.2 47.601n 0 48.0n 0 48.001n 1.2 48.6n 1.2 48.601n 0 49.0n 0 49.001n 1.2 49.6n 1.2 49.601n 0 50.0n 0 50.001n 1.2 50.6n 1.2 50.601n 0 51.0n 0 51.001n 1.2 51.6n 1.2 51.601n 0 52.0n 0 52.001n 1.2 52.6n 1.2 52.601n 0 53.0n 0 53.001n 1.2 53.6n 1.2 53.601n 0 54.0n 0 54.001n 1.2 54.6n 1.2 54.601n 0 55.0n 0 55.001n 1.2 55.6n 1.2 55.601n 0 56.0n 0 56.001n 1.2 56.6n 1.2 56.601n 0 57.0n 0 57.001n 1.2 57.6n 1.2 57.601n 0 58.0n 0 58.001n 1.2 58.6n 1.2 58.601n 0 59.0n 0 59.001n 1.2 59.6n 1.2 59.601n 0 60.0n 0 60.001n 1.2 60.6n 1.2 60.601n 0 61.0n 0 61.001n 1.2 61.6n 1.2 61.601n 0 62.0n 0 62.001n 1.2 62.6n 1.2 62.601n 0 63.0n 0 63.001n 1.2 63.6n 1.2 63.601n 0 64.0n 0 64.001n 1.2 64.6n 1.2 64.601n 0 65.0n 0 65.001n 1.2 65.6n 1.2 65.601n 0 66.0n 0 66.001n 1.2 66.6n 1.2 66.601n 0 67.0n 0 67.001n 1.2 67.6n 1.2 67.601n 0 68.0n 0 68.001n 1.2 68.6n 1.2 68.601n 0 69.0n 0 69.001n 1.2 69.6n 1.2 69.601n 0 70.0n 0 70.001n 1.2 70.6n 1.2 70.601n 0 71.0n 0 71.001n 1.2 71.6n 1.2 71.601n 0 72.0n 0 72.001n 1.2 72.6n 1.2 72.601n 0 73.0n 0 73.001n 1.2 73.6n 1.2 73.601n 0 74.0n 0 74.001n 1.2 74.6n 1.2 74.601n 0 75.0n 0 75.001n 1.2 75.6n 1.2 75.601n 0 76.0n 0 76.001n 1.2 76.6n 1.2 76.601n 0 77.0n 0 77.001n 1.2 77.6n 1.2 77.601n 0 78.0n 0 78.001n 1.2 78.6n 1.2 78.601n 0 79.0n 0 79.001n 1.2 79.6n 1.2 79.601n 0 80.0n 0 80.001n 1.2 80.6n 1.2 80.601n 0 81.0n 0 81.001n 1.2 81.6n 1.2 81.601n 0 82.0n 0 82.001n 1.2 82.6n 1.2 82.601n 0 83.0n 0 83.001n 1.2 83.6n 1.2 83.601n 0 84.0n 0 84.001n 1.2 84.6n 1.2 84.601n 0 85.0n 0 85.001n 1.2 85.6n 1.2 85.601n 0 86.0n 0 86.001n 1.2 86.6n 1.2 86.601n 0 87.0n 0 87.001n 1.2 87.6n 1.2 87.601n 0 88.0n 0 88.001n 1.2 88.6n 1.2 88.601n 0 89.0n 0 89.001n 1.2 89.6n 1.2 89.601n 0 90.0n 0 90.001n 1.2 90.6n 1.2 90.601n 0 91.0n 0 91.001n 1.2 91.6n 1.2 91.601n 0 92.0n 0 92.001n 1.2 92.6n 1.2 92.601n 0 93.0n 0 93.001n 1.2 93.6n 1.2 93.601n 0 94.0n 0 94.001n 1.2 94.6n 1.2 94.601n 0 95.0n 0 95.001n 1.2 95.6n 1.2 95.601n 0 96.0n 0 96.001n 1.2 96.6n 1.2 96.601n 0 97.0n 0 97.001n 1.2 97.6n 1.2 97.601n 0 98.0n 0 98.001n 1.2 98.6n 1.2 98.601n 0 99.0n 0 99.001n 1.2 99.6n 1.2 99.601n 0 100.0n 0 100.001n 1.2 100.6n 1.2 100.601n 0 101.0n 0 101.001n 1.2 101.6n 1.2 101.601n 0 102.0n 0 102.001n 1.2 102.6n 1.2 102.601n 0 103.0n 0 103.001n 1.2 103.6n 1.2 103.601n 0 104.0n 0 104.001n 1.2 104.6n 1.2 104.601n 0 105.0n 0 105.001n 1.2 105.6n 1.2 105.601n 0 106.0n 0 106.001n 1.2 106.6n 1.2 106.601n 0 107.0n 0 107.001n 1.2 107.6n 1.2 107.601n 0 108.0n 0 108.001n 1.2 108.6n 1.2 108.601n 0 109.0n 0 109.001n 1.2 109.6n 1.2 109.601n 0 110.0n 0 110.001n 1.2 110.6n 1.2 110.601n 0 111.0n 0 111.001n 1.2 111.6n 1.2 111.601n 0 112.0n 0 112.001n 1.2 112.6n 1.2 112.601n 0 113.0n 0 113.001n 1.2 113.6n 1.2 113.601n 0 114.0n 0 114.001n 1.2 114.6n 1.2 114.601n 0 115.0n 0 115.001n 1.2 115.6n 1.2 115.601n 0 116.0n 0 116.001n 1.2 116.6n 1.2 116.601n 0 117.0n 0 117.001n 1.2 117.6n 1.2 117.601n 0 118.0n 0 118.001n 1.2 118.6n 1.2 118.601n 0 119.0n 0 119.001n 1.2 119.6n 1.2 119.601n 0 120.0n 0 120.001n 1.2 120.6n 1.2 120.601n 0 121.0n 0 121.001n 1.2 121.6n 1.2 121.601n 0 122.0n 0 122.001n 1.2 122.6n 1.2 122.601n 0 123.0n 0 123.001n 1.2 123.6n 1.2 123.601n 0 124.0n 0 124.001n 1.2 124.6n 1.2 124.601n 0 125.0n 0 125.001n 1.2 125.6n 1.2 125.601n 0 126.0n 0 126.001n 1.2 126.6n 1.2 126.601n 0 127.0n 0 127.001n 1.2 127.6n 1.2 127.601n 0 128.0n 0 128.001n 1.2 128.6n 1.2 128.601n 0 129.0n 0 129.001n 1.2 129.6n 1.2 129.601n 0 130.0n 0 130.001n 1.2 130.6n 1.2 130.601n 0 131.0n 0 131.001n 1.2 131.6n 1.2 131.601n 0 132.0n 0 132.001n 1.2 132.6n 1.2 132.601n 0 133.0n 0 133.001n 1.2 133.6n 1.2 133.601n 0 134.0n 0 134.001n 1.2 134.6n 1.2 134.601n 0 135.0n 0 135.001n 1.2 135.6n 1.2 135.601n 0 136.0n 0 136.001n 1.2 136.6n 1.2 136.601n 0 137.0n 0 137.001n 1.2 137.6n 1.2 137.601n 0 138.0n 0 138.001n 1.2 138.6n 1.2 138.601n 0 139.0n 0 139.001n 1.2 139.6n 1.2 139.601n 0 140.0n 0 140.001n 1.2 140.6n 1.2 140.601n 0 141.0n 0 141.001n 1.2 141.6n 1.2 141.601n 0 142.0n 0 142.001n 1.2 142.6n 1.2 142.601n 0 143.0n 0 143.001n 1.2 143.6n 1.2 143.601n 0 144.0n 0 144.001n 1.2 144.6n 1.2 144.601n 0 145.0n 0 145.001n 1.2 145.6n 1.2 145.601n 0 146.0n 0 146.001n 1.2 146.6n 1.2 146.601n 0 147.0n 0 147.001n 1.2 147.6n 1.2 147.601n 0 148.0n 0 148.001n 1.2 148.6n 1.2 148.601n 0 149.0n 0 149.001n 1.2 149.6n 1.2 149.601n 0 150.0n 0 150.001n 1.2 150.6n 1.2 150.601n 0 151.0n 0 151.001n 1.2 151.6n 1.2 151.601n 0 152.0n 0 152.001n 1.2 152.6n 1.2 152.601n 0 153.0n 0 153.001n 1.2 153.6n 1.2 153.601n 0 154.0n 0 154.001n 1.2 154.6n 1.2 154.601n 0 155.0n 0 155.001n 1.2 155.6n 1.2 155.601n 0 156.0n 0 156.001n 1.2 156.6n 1.2 156.601n 0 157.0n 0 157.001n 1.2 157.6n 1.2 157.601n 0 158.0n 0 158.001n 1.2 158.6n 1.2 158.601n 0 159.0n 0 159.001n 1.2 159.6n 1.2 159.601n 0 160.0n 0 160.001n 1.2 160.6n 1.2 160.601n 0 161.0n 0 161.001n 1.2 161.6n 1.2 161.601n 0 162.0n 0 162.001n 1.2 162.6n 1.2 162.601n 0 163.0n 0 163.001n 1.2 163.6n 1.2 163.601n 0 164.0n 0 164.001n 1.2 164.6n 1.2 164.601n 0 165.0n 0 165.001n 1.2 165.6n 1.2 165.601n 0 166.0n 0 166.001n 1.2 166.6n 1.2 166.601n 0 167.0n 0 167.001n 1.2 167.6n 1.2 167.601n 0 168.0n 0 168.001n 1.2 168.6n 1.2 168.601n 0 169.0n 0 169.001n 1.2 169.6n 1.2 169.601n 0 170.0n 0 170.001n 1.2 170.6n 1.2 170.601n 0 171.0n 0 171.001n 1.2 171.6n 1.2 171.601n 0 172.0n 0 172.001n 1.2 172.6n 1.2 172.601n 0 173.0n 0 173.001n 1.2 173.6n 1.2 173.601n 0 174.0n 0 174.001n 1.2 174.6n 1.2 174.601n 0 175.0n 0 175.001n 1.2 175.6n 1.2 175.601n 0 176.0n 0 176.001n 1.2 176.6n 1.2 176.601n 0 177.0n 0 177.001n 1.2 177.6n 1.2 177.601n 0 178.0n 0 178.001n 1.2 178.6n 1.2 178.601n 0 179.0n 0 179.001n 1.2 179.6n 1.2 179.601n 0 180.0n 0 180.001n 1.2 180.6n 1.2 180.601n 0 181.0n 0 181.001n 1.2 181.6n 1.2 181.601n 0 182.0n 0 182.001n 1.2 182.6n 1.2 182.601n 0 183.0n 0 183.001n 1.2 183.6n 1.2 183.601n 0 184.0n 0 184.001n 1.2 184.6n 1.2 184.601n 0 185.0n 0 185.001n 1.2 185.6n 1.2 185.601n 0 186.0n 0 186.001n 1.2 186.6n 1.2 186.601n 0 187.0n 0 187.001n 1.2 187.6n 1.2 187.601n 0 188.0n 0 188.001n 1.2 188.6n 1.2 188.601n 0 189.0n 0 189.001n 1.2 189.6n 1.2 189.601n 0 190.0n 0 190.001n 1.2 190.6n 1.2 190.601n 0 191.0n 0 191.001n 1.2 191.6n 1.2 191.601n 0 192.0n 0 192.001n 1.2 192.6n 1.2 192.601n 0 193.0n 0 193.001n 1.2 193.6n 1.2 193.601n 0 194.0n 0 194.001n 1.2 194.6n 1.2 194.601n 0 195.0n 0 195.001n 1.2 195.6n 1.2 195.601n 0 196.0n 0 196.001n 1.2 196.6n 1.2 196.601n 0 197.0n 0 197.001n 1.2 197.6n 1.2 197.601n 0 198.0n 0 198.001n 1.2 198.6n 1.2 198.601n 0 199.0n 0 199.001n 1.2 199.6n 1.2 199.601n 0 200.0n 0 200.001n 1.2 200.6n 1.2 200.601n 0 201.0n 0 201.001n 1.2 201.6n 1.2 201.601n 0 202.0n 0 202.001n 1.2 202.6n 1.2 202.601n 0 203.0n 0 203.001n 1.2 203.6n 1.2 203.601n 0 204.0n 0 204.001n 1.2 204.6n 1.2 204.601n 0 205.0n 0 205.001n 1.2 205.6n 1.2 205.601n 0 206.0n 0 206.001n 1.2 206.6n 1.2 206.601n 0 207.0n 0 207.001n 1.2 207.6n 1.2 207.601n 0 208.0n 0 208.001n 1.2 208.6n 1.2 208.601n 0 209.0n 0 209.001n 1.2 209.6n 1.2 209.601n 0 210.0n 0 210.001n 1.2 210.6n 1.2 210.601n 0 211.0n 0 211.001n 1.2 211.6n 1.2 211.601n 0 212.0n 0 212.001n 1.2 212.6n 1.2 212.601n 0 213.0n 0 213.001n 1.2 213.6n 1.2 213.601n 0 214.0n 0 214.001n 1.2 214.6n 1.2 214.601n 0 215.0n 0 215.001n 1.2 215.6n 1.2 215.601n 0 216.0n 0 216.001n 1.2 216.6n 1.2 216.601n 0 217.0n 0 217.001n 1.2 217.6n 1.2 217.601n 0 218.0n 0 218.001n 1.2 218.6n 1.2 218.601n 0 219.0n 0 219.001n 1.2 219.6n 1.2 219.601n 0 220.0n 0 220.001n 1.2 220.6n 1.2 220.601n 0 221.0n 0 221.001n 1.2 221.6n 1.2 221.601n 0 222.0n 0 222.001n 1.2 222.6n 1.2 222.601n 0 223.0n 0 223.001n 1.2 223.6n 1.2 223.601n 0 224.0n 0 224.001n 1.2 224.6n 1.2 224.601n 0 225.0n 0 225.001n 1.2 225.6n 1.2 225.601n 0 226.0n 0 226.001n 1.2 226.6n 1.2 226.601n 0 227.0n 0 227.001n 1.2 227.6n 1.2 227.601n 0 228.0n 0 228.001n 1.2 228.6n 1.2 228.601n 0 229.0n 0 229.001n 1.2 229.6n 1.2 229.601n 0 230.0n 0 230.001n 1.2 230.6n 1.2 230.601n 0 231.0n 0 231.001n 1.2 231.6n 1.2 231.601n 0 232.0n 0 232.001n 1.2 232.6n 1.2 232.601n 0 233.0n 0 233.001n 1.2 233.6n 1.2 233.601n 0 234.0n 0 234.001n 1.2 234.6n 1.2 234.601n 0 235.0n 0 235.001n 1.2 235.6n 1.2 235.601n 0 236.0n 0 236.001n 1.2 236.6n 1.2 236.601n 0 237.0n 0 237.001n 1.2 237.6n 1.2 237.601n 0 238.0n 0 238.001n 1.2 238.6n 1.2 238.601n 0 239.0n 0 239.001n 1.2 239.6n 1.2 239.601n 0 240.0n 0 240.001n 1.2 240.6n 1.2 240.601n 0 241.0n 0 241.001n 1.2 241.6n 1.2 241.601n 0 242.0n 0 242.001n 1.2 242.6n 1.2 242.601n 0 243.0n 0 243.001n 1.2 243.6n 1.2 243.601n 0 244.0n 0 244.001n 1.2 244.6n 1.2 244.601n 0 245.0n 0 245.001n 1.2 245.6n 1.2 245.601n 0 246.0n 0 246.001n 1.2 246.6n 1.2 246.601n 0 247.0n 0 247.001n 1.2 247.6n 1.2 247.601n 0 248.0n 0 248.001n 1.2 248.6n 1.2 248.601n 0 249.0n 0 249.001n 1.2 249.6n 1.2 249.601n 0 250.0n 0 250.001n 1.2 250.6n 1.2 250.601n 0 251.0n 0 251.001n 1.2 251.6n 1.2 251.601n 0 252.0n 0 252.001n 1.2 252.6n 1.2 252.601n 0 253.0n 0 253.001n 1.2 253.6n 1.2 253.601n 0 254.0n 0 254.001n 1.2 254.6n 1.2 254.601n 0 255.0n 0 255.001n 1.2 255.6n 1.2 255.601n 0 256.0n 0 256.001n 1.2 256.6n 1.2 256.601n 0 ]

// Worldline Signal
Vwl1 (WL1 0) vsource type=pwl wave=[0 0 1.0n 0 1.001n 0.3 1.4n 0.3 1.401n 0 2.0n 0 2.001n 0.3466666666666667 2.4n 0.3466666666666667 2.401n 0 3.0n 0 3.001n 0.3933333333333333 3.4n 0.3933333333333333 3.401n 0 4.0n 0 4.001n 0.43999999999999995 4.4n 0.43999999999999995 4.401n 0 5.0n 0 5.001n 0.48666666666666664 5.4n 0.48666666666666664 5.401n 0 6.0n 0 6.001n 0.5333333333333333 6.4n 0.5333333333333333 6.401n 0 7.0n 0 7.001n 0.58 7.4n 0.58 7.401n 0 8.0n 0 8.001n 0.6266666666666666 8.4n 0.6266666666666666 8.401n 0 9.0n 0 9.001n 0.6733333333333333 9.4n 0.6733333333333333 9.401n 0 10.0n 0 10.001n 0.72 10.4n 0.72 10.401n 0 11.0n 0 11.001n 0.7666666666666666 11.4n 0.7666666666666666 11.401n 0 12.0n 0 12.001n 0.8133333333333332 12.4n 0.8133333333333332 12.401n 0 13.0n 0 13.001n 0.8599999999999999 13.4n 0.8599999999999999 13.401n 0 14.0n 0 14.001n 0.9066666666666667 14.4n 0.9066666666666667 14.401n 0 15.0n 0 15.001n 0.9533333333333331 15.4n 0.9533333333333331 15.401n 0 16.0n 0 16.001n 1.0 16.4n 1.0 16.401n 0 ]
Vwl2 (WL2 0) vsource type=pwl wave=[0 0 17.0n 0 17.001n 0.3 17.4n 0.3 17.401n 0 18.0n 0 18.001n 0.3466666666666667 18.4n 0.3466666666666667 18.401n 0 19.0n 0 19.001n 0.3933333333333333 19.4n 0.3933333333333333 19.401n 0 20.0n 0 20.001n 0.43999999999999995 20.4n 0.43999999999999995 20.401n 0 21.0n 0 21.001n 0.48666666666666664 21.4n 0.48666666666666664 21.401n 0 22.0n 0 22.001n 0.5333333333333333 22.4n 0.5333333333333333 22.401n 0 23.0n 0 23.001n 0.58 23.4n 0.58 23.401n 0 24.0n 0 24.001n 0.6266666666666666 24.4n 0.6266666666666666 24.401n 0 25.0n 0 25.001n 0.6733333333333333 25.4n 0.6733333333333333 25.401n 0 26.0n 0 26.001n 0.72 26.4n 0.72 26.401n 0 27.0n 0 27.001n 0.7666666666666666 27.4n 0.7666666666666666 27.401n 0 28.0n 0 28.001n 0.8133333333333332 28.4n 0.8133333333333332 28.401n 0 29.0n 0 29.001n 0.8599999999999999 29.4n 0.8599999999999999 29.401n 0 30.0n 0 30.001n 0.9066666666666667 30.4n 0.9066666666666667 30.401n 0 31.0n 0 31.001n 0.9533333333333331 31.4n 0.9533333333333331 31.401n 0 32.0n 0 32.001n 1.0 32.4n 1.0 32.401n 0 ]
Vwl3 (WL3 0) vsource type=pwl wave=[0 0 33.0n 0 33.001n 0.3 33.4n 0.3 33.401n 0 34.0n 0 34.001n 0.3466666666666667 34.4n 0.3466666666666667 34.401n 0 35.0n 0 35.001n 0.3933333333333333 35.4n 0.3933333333333333 35.401n 0 36.0n 0 36.001n 0.43999999999999995 36.4n 0.43999999999999995 36.401n 0 37.0n 0 37.001n 0.48666666666666664 37.4n 0.48666666666666664 37.401n 0 38.0n 0 38.001n 0.5333333333333333 38.4n 0.5333333333333333 38.401n 0 39.0n 0 39.001n 0.58 39.4n 0.58 39.401n 0 40.0n 0 40.001n 0.6266666666666666 40.4n 0.6266666666666666 40.401n 0 41.0n 0 41.001n 0.6733333333333333 41.4n 0.6733333333333333 41.401n 0 42.0n 0 42.001n 0.72 42.4n 0.72 42.401n 0 43.0n 0 43.001n 0.7666666666666666 43.4n 0.7666666666666666 43.401n 0 44.0n 0 44.001n 0.8133333333333332 44.4n 0.8133333333333332 44.401n 0 45.0n 0 45.001n 0.8599999999999999 45.4n 0.8599999999999999 45.401n 0 46.0n 0 46.001n 0.9066666666666667 46.4n 0.9066666666666667 46.401n 0 47.0n 0 47.001n 0.9533333333333331 47.4n 0.9533333333333331 47.401n 0 48.0n 0 48.001n 1.0 48.4n 1.0 48.401n 0 ]
Vwl4 (WL4 0) vsource type=pwl wave=[0 0 49.0n 0 49.001n 0.3 49.4n 0.3 49.401n 0 50.0n 0 50.001n 0.3466666666666667 50.4n 0.3466666666666667 50.401n 0 51.0n 0 51.001n 0.3933333333333333 51.4n 0.3933333333333333 51.401n 0 52.0n 0 52.001n 0.43999999999999995 52.4n 0.43999999999999995 52.401n 0 53.0n 0 53.001n 0.48666666666666664 53.4n 0.48666666666666664 53.401n 0 54.0n 0 54.001n 0.5333333333333333 54.4n 0.5333333333333333 54.401n 0 55.0n 0 55.001n 0.58 55.4n 0.58 55.401n 0 56.0n 0 56.001n 0.6266666666666666 56.4n 0.6266666666666666 56.401n 0 57.0n 0 57.001n 0.6733333333333333 57.4n 0.6733333333333333 57.401n 0 58.0n 0 58.001n 0.72 58.4n 0.72 58.401n 0 59.0n 0 59.001n 0.7666666666666666 59.4n 0.7666666666666666 59.401n 0 60.0n 0 60.001n 0.8133333333333332 60.4n 0.8133333333333332 60.401n 0 61.0n 0 61.001n 0.8599999999999999 61.4n 0.8599999999999999 61.401n 0 62.0n 0 62.001n 0.9066666666666667 62.4n 0.9066666666666667 62.401n 0 63.0n 0 63.001n 0.9533333333333331 63.4n 0.9533333333333331 63.401n 0 64.0n 0 64.001n 1.0 64.4n 1.0 64.401n 0 ]
Vwl5 (WL5 0) vsource type=pwl wave=[0 0 65.0n 0 65.001n 0.3 65.4n 0.3 65.401n 0 66.0n 0 66.001n 0.3466666666666667 66.4n 0.3466666666666667 66.401n 0 67.0n 0 67.001n 0.3933333333333333 67.4n 0.3933333333333333 67.401n 0 68.0n 0 68.001n 0.43999999999999995 68.4n 0.43999999999999995 68.401n 0 69.0n 0 69.001n 0.48666666666666664 69.4n 0.48666666666666664 69.401n 0 70.0n 0 70.001n 0.5333333333333333 70.4n 0.5333333333333333 70.401n 0 71.0n 0 71.001n 0.58 71.4n 0.58 71.401n 0 72.0n 0 72.001n 0.6266666666666666 72.4n 0.6266666666666666 72.401n 0 73.0n 0 73.001n 0.6733333333333333 73.4n 0.6733333333333333 73.401n 0 74.0n 0 74.001n 0.72 74.4n 0.72 74.401n 0 75.0n 0 75.001n 0.7666666666666666 75.4n 0.7666666666666666 75.401n 0 76.0n 0 76.001n 0.8133333333333332 76.4n 0.8133333333333332 76.401n 0 77.0n 0 77.001n 0.8599999999999999 77.4n 0.8599999999999999 77.401n 0 78.0n 0 78.001n 0.9066666666666667 78.4n 0.9066666666666667 78.401n 0 79.0n 0 79.001n 0.9533333333333331 79.4n 0.9533333333333331 79.401n 0 80.0n 0 80.001n 1.0 80.4n 1.0 80.401n 0 ]
Vwl6 (WL6 0) vsource type=pwl wave=[0 0 81.0n 0 81.001n 0.3 81.4n 0.3 81.401n 0 82.0n 0 82.001n 0.3466666666666667 82.4n 0.3466666666666667 82.401n 0 83.0n 0 83.001n 0.3933333333333333 83.4n 0.3933333333333333 83.401n 0 84.0n 0 84.001n 0.43999999999999995 84.4n 0.43999999999999995 84.401n 0 85.0n 0 85.001n 0.48666666666666664 85.4n 0.48666666666666664 85.401n 0 86.0n 0 86.001n 0.5333333333333333 86.4n 0.5333333333333333 86.401n 0 87.0n 0 87.001n 0.58 87.4n 0.58 87.401n 0 88.0n 0 88.001n 0.6266666666666666 88.4n 0.6266666666666666 88.401n 0 89.0n 0 89.001n 0.6733333333333333 89.4n 0.6733333333333333 89.401n 0 90.0n 0 90.001n 0.72 90.4n 0.72 90.401n 0 91.0n 0 91.001n 0.7666666666666666 91.4n 0.7666666666666666 91.401n 0 92.0n 0 92.001n 0.8133333333333332 92.4n 0.8133333333333332 92.401n 0 93.0n 0 93.001n 0.8599999999999999 93.4n 0.8599999999999999 93.401n 0 94.0n 0 94.001n 0.9066666666666667 94.4n 0.9066666666666667 94.401n 0 95.0n 0 95.001n 0.9533333333333331 95.4n 0.9533333333333331 95.401n 0 96.0n 0 96.001n 1.0 96.4n 1.0 96.401n 0 ]
Vwl7 (WL7 0) vsource type=pwl wave=[0 0 97.0n 0 97.001n 0.3 97.4n 0.3 97.401n 0 98.0n 0 98.001n 0.3466666666666667 98.4n 0.3466666666666667 98.401n 0 99.0n 0 99.001n 0.3933333333333333 99.4n 0.3933333333333333 99.401n 0 100.0n 0 100.001n 0.43999999999999995 100.4n 0.43999999999999995 100.401n 0 101.0n 0 101.001n 0.48666666666666664 101.4n 0.48666666666666664 101.401n 0 102.0n 0 102.001n 0.5333333333333333 102.4n 0.5333333333333333 102.401n 0 103.0n 0 103.001n 0.58 103.4n 0.58 103.401n 0 104.0n 0 104.001n 0.6266666666666666 104.4n 0.6266666666666666 104.401n 0 105.0n 0 105.001n 0.6733333333333333 105.4n 0.6733333333333333 105.401n 0 106.0n 0 106.001n 0.72 106.4n 0.72 106.401n 0 107.0n 0 107.001n 0.7666666666666666 107.4n 0.7666666666666666 107.401n 0 108.0n 0 108.001n 0.8133333333333332 108.4n 0.8133333333333332 108.401n 0 109.0n 0 109.001n 0.8599999999999999 109.4n 0.8599999999999999 109.401n 0 110.0n 0 110.001n 0.9066666666666667 110.4n 0.9066666666666667 110.401n 0 111.0n 0 111.001n 0.9533333333333331 111.4n 0.9533333333333331 111.401n 0 112.0n 0 112.001n 1.0 112.4n 1.0 112.401n 0 ]
Vwl8 (WL8 0) vsource type=pwl wave=[0 0 113.0n 0 113.001n 0.3 113.4n 0.3 113.401n 0 114.0n 0 114.001n 0.3466666666666667 114.4n 0.3466666666666667 114.401n 0 115.0n 0 115.001n 0.3933333333333333 115.4n 0.3933333333333333 115.401n 0 116.0n 0 116.001n 0.43999999999999995 116.4n 0.43999999999999995 116.401n 0 117.0n 0 117.001n 0.48666666666666664 117.4n 0.48666666666666664 117.401n 0 118.0n 0 118.001n 0.5333333333333333 118.4n 0.5333333333333333 118.401n 0 119.0n 0 119.001n 0.58 119.4n 0.58 119.401n 0 120.0n 0 120.001n 0.6266666666666666 120.4n 0.6266666666666666 120.401n 0 121.0n 0 121.001n 0.6733333333333333 121.4n 0.6733333333333333 121.401n 0 122.0n 0 122.001n 0.72 122.4n 0.72 122.401n 0 123.0n 0 123.001n 0.7666666666666666 123.4n 0.7666666666666666 123.401n 0 124.0n 0 124.001n 0.8133333333333332 124.4n 0.8133333333333332 124.401n 0 125.0n 0 125.001n 0.8599999999999999 125.4n 0.8599999999999999 125.401n 0 126.0n 0 126.001n 0.9066666666666667 126.4n 0.9066666666666667 126.401n 0 127.0n 0 127.001n 0.9533333333333331 127.4n 0.9533333333333331 127.401n 0 128.0n 0 128.001n 1.0 128.4n 1.0 128.401n 0 ]
Vwl9 (WL9 0) vsource type=pwl wave=[0 0 129.0n 0 129.001n 0.3 129.4n 0.3 129.401n 0 130.0n 0 130.001n 0.3466666666666667 130.4n 0.3466666666666667 130.401n 0 131.0n 0 131.001n 0.3933333333333333 131.4n 0.3933333333333333 131.401n 0 132.0n 0 132.001n 0.43999999999999995 132.4n 0.43999999999999995 132.401n 0 133.0n 0 133.001n 0.48666666666666664 133.4n 0.48666666666666664 133.401n 0 134.0n 0 134.001n 0.5333333333333333 134.4n 0.5333333333333333 134.401n 0 135.0n 0 135.001n 0.58 135.4n 0.58 135.401n 0 136.0n 0 136.001n 0.6266666666666666 136.4n 0.6266666666666666 136.401n 0 137.0n 0 137.001n 0.6733333333333333 137.4n 0.6733333333333333 137.401n 0 138.0n 0 138.001n 0.72 138.4n 0.72 138.401n 0 139.0n 0 139.001n 0.7666666666666666 139.4n 0.7666666666666666 139.401n 0 140.0n 0 140.001n 0.8133333333333332 140.4n 0.8133333333333332 140.401n 0 141.0n 0 141.001n 0.8599999999999999 141.4n 0.8599999999999999 141.401n 0 142.0n 0 142.001n 0.9066666666666667 142.4n 0.9066666666666667 142.401n 0 143.0n 0 143.001n 0.9533333333333331 143.4n 0.9533333333333331 143.401n 0 144.0n 0 144.001n 1.0 144.4n 1.0 144.401n 0 ]
Vwl10 (WL10 0) vsource type=pwl wave=[0 0 145.0n 0 145.001n 0.3 145.4n 0.3 145.401n 0 146.0n 0 146.001n 0.3466666666666667 146.4n 0.3466666666666667 146.401n 0 147.0n 0 147.001n 0.3933333333333333 147.4n 0.3933333333333333 147.401n 0 148.0n 0 148.001n 0.43999999999999995 148.4n 0.43999999999999995 148.401n 0 149.0n 0 149.001n 0.48666666666666664 149.4n 0.48666666666666664 149.401n 0 150.0n 0 150.001n 0.5333333333333333 150.4n 0.5333333333333333 150.401n 0 151.0n 0 151.001n 0.58 151.4n 0.58 151.401n 0 152.0n 0 152.001n 0.6266666666666666 152.4n 0.6266666666666666 152.401n 0 153.0n 0 153.001n 0.6733333333333333 153.4n 0.6733333333333333 153.401n 0 154.0n 0 154.001n 0.72 154.4n 0.72 154.401n 0 155.0n 0 155.001n 0.7666666666666666 155.4n 0.7666666666666666 155.401n 0 156.0n 0 156.001n 0.8133333333333332 156.4n 0.8133333333333332 156.401n 0 157.0n 0 157.001n 0.8599999999999999 157.4n 0.8599999999999999 157.401n 0 158.0n 0 158.001n 0.9066666666666667 158.4n 0.9066666666666667 158.401n 0 159.0n 0 159.001n 0.9533333333333331 159.4n 0.9533333333333331 159.401n 0 160.0n 0 160.001n 1.0 160.4n 1.0 160.401n 0 ]
Vwl11 (WL11 0) vsource type=pwl wave=[0 0 161.0n 0 161.001n 0.3 161.4n 0.3 161.401n 0 162.0n 0 162.001n 0.3466666666666667 162.4n 0.3466666666666667 162.401n 0 163.0n 0 163.001n 0.3933333333333333 163.4n 0.3933333333333333 163.401n 0 164.0n 0 164.001n 0.43999999999999995 164.4n 0.43999999999999995 164.401n 0 165.0n 0 165.001n 0.48666666666666664 165.4n 0.48666666666666664 165.401n 0 166.0n 0 166.001n 0.5333333333333333 166.4n 0.5333333333333333 166.401n 0 167.0n 0 167.001n 0.58 167.4n 0.58 167.401n 0 168.0n 0 168.001n 0.6266666666666666 168.4n 0.6266666666666666 168.401n 0 169.0n 0 169.001n 0.6733333333333333 169.4n 0.6733333333333333 169.401n 0 170.0n 0 170.001n 0.72 170.4n 0.72 170.401n 0 171.0n 0 171.001n 0.7666666666666666 171.4n 0.7666666666666666 171.401n 0 172.0n 0 172.001n 0.8133333333333332 172.4n 0.8133333333333332 172.401n 0 173.0n 0 173.001n 0.8599999999999999 173.4n 0.8599999999999999 173.401n 0 174.0n 0 174.001n 0.9066666666666667 174.4n 0.9066666666666667 174.401n 0 175.0n 0 175.001n 0.9533333333333331 175.4n 0.9533333333333331 175.401n 0 176.0n 0 176.001n 1.0 176.4n 1.0 176.401n 0 ]
Vwl12 (WL12 0) vsource type=pwl wave=[0 0 177.0n 0 177.001n 0.3 177.4n 0.3 177.401n 0 178.0n 0 178.001n 0.3466666666666667 178.4n 0.3466666666666667 178.401n 0 179.0n 0 179.001n 0.3933333333333333 179.4n 0.3933333333333333 179.401n 0 180.0n 0 180.001n 0.43999999999999995 180.4n 0.43999999999999995 180.401n 0 181.0n 0 181.001n 0.48666666666666664 181.4n 0.48666666666666664 181.401n 0 182.0n 0 182.001n 0.5333333333333333 182.4n 0.5333333333333333 182.401n 0 183.0n 0 183.001n 0.58 183.4n 0.58 183.401n 0 184.0n 0 184.001n 0.6266666666666666 184.4n 0.6266666666666666 184.401n 0 185.0n 0 185.001n 0.6733333333333333 185.4n 0.6733333333333333 185.401n 0 186.0n 0 186.001n 0.72 186.4n 0.72 186.401n 0 187.0n 0 187.001n 0.7666666666666666 187.4n 0.7666666666666666 187.401n 0 188.0n 0 188.001n 0.8133333333333332 188.4n 0.8133333333333332 188.401n 0 189.0n 0 189.001n 0.8599999999999999 189.4n 0.8599999999999999 189.401n 0 190.0n 0 190.001n 0.9066666666666667 190.4n 0.9066666666666667 190.401n 0 191.0n 0 191.001n 0.9533333333333331 191.4n 0.9533333333333331 191.401n 0 192.0n 0 192.001n 1.0 192.4n 1.0 192.401n 0 ]
Vwl13 (WL13 0) vsource type=pwl wave=[0 0 193.0n 0 193.001n 0.3 193.4n 0.3 193.401n 0 194.0n 0 194.001n 0.3466666666666667 194.4n 0.3466666666666667 194.401n 0 195.0n 0 195.001n 0.3933333333333333 195.4n 0.3933333333333333 195.401n 0 196.0n 0 196.001n 0.43999999999999995 196.4n 0.43999999999999995 196.401n 0 197.0n 0 197.001n 0.48666666666666664 197.4n 0.48666666666666664 197.401n 0 198.0n 0 198.001n 0.5333333333333333 198.4n 0.5333333333333333 198.401n 0 199.0n 0 199.001n 0.58 199.4n 0.58 199.401n 0 200.0n 0 200.001n 0.6266666666666666 200.4n 0.6266666666666666 200.401n 0 201.0n 0 201.001n 0.6733333333333333 201.4n 0.6733333333333333 201.401n 0 202.0n 0 202.001n 0.72 202.4n 0.72 202.401n 0 203.0n 0 203.001n 0.7666666666666666 203.4n 0.7666666666666666 203.401n 0 204.0n 0 204.001n 0.8133333333333332 204.4n 0.8133333333333332 204.401n 0 205.0n 0 205.001n 0.8599999999999999 205.4n 0.8599999999999999 205.401n 0 206.0n 0 206.001n 0.9066666666666667 206.4n 0.9066666666666667 206.401n 0 207.0n 0 207.001n 0.9533333333333331 207.4n 0.9533333333333331 207.401n 0 208.0n 0 208.001n 1.0 208.4n 1.0 208.401n 0 ]
Vwl14 (WL14 0) vsource type=pwl wave=[0 0 209.0n 0 209.001n 0.3 209.4n 0.3 209.401n 0 210.0n 0 210.001n 0.3466666666666667 210.4n 0.3466666666666667 210.401n 0 211.0n 0 211.001n 0.3933333333333333 211.4n 0.3933333333333333 211.401n 0 212.0n 0 212.001n 0.43999999999999995 212.4n 0.43999999999999995 212.401n 0 213.0n 0 213.001n 0.48666666666666664 213.4n 0.48666666666666664 213.401n 0 214.0n 0 214.001n 0.5333333333333333 214.4n 0.5333333333333333 214.401n 0 215.0n 0 215.001n 0.58 215.4n 0.58 215.401n 0 216.0n 0 216.001n 0.6266666666666666 216.4n 0.6266666666666666 216.401n 0 217.0n 0 217.001n 0.6733333333333333 217.4n 0.6733333333333333 217.401n 0 218.0n 0 218.001n 0.72 218.4n 0.72 218.401n 0 219.0n 0 219.001n 0.7666666666666666 219.4n 0.7666666666666666 219.401n 0 220.0n 0 220.001n 0.8133333333333332 220.4n 0.8133333333333332 220.401n 0 221.0n 0 221.001n 0.8599999999999999 221.4n 0.8599999999999999 221.401n 0 222.0n 0 222.001n 0.9066666666666667 222.4n 0.9066666666666667 222.401n 0 223.0n 0 223.001n 0.9533333333333331 223.4n 0.9533333333333331 223.401n 0 224.0n 0 224.001n 1.0 224.4n 1.0 224.401n 0 ]
Vwl15 (WL15 0) vsource type=pwl wave=[0 0 225.0n 0 225.001n 0.3 225.4n 0.3 225.401n 0 226.0n 0 226.001n 0.3466666666666667 226.4n 0.3466666666666667 226.401n 0 227.0n 0 227.001n 0.3933333333333333 227.4n 0.3933333333333333 227.401n 0 228.0n 0 228.001n 0.43999999999999995 228.4n 0.43999999999999995 228.401n 0 229.0n 0 229.001n 0.48666666666666664 229.4n 0.48666666666666664 229.401n 0 230.0n 0 230.001n 0.5333333333333333 230.4n 0.5333333333333333 230.401n 0 231.0n 0 231.001n 0.58 231.4n 0.58 231.401n 0 232.0n 0 232.001n 0.6266666666666666 232.4n 0.6266666666666666 232.401n 0 233.0n 0 233.001n 0.6733333333333333 233.4n 0.6733333333333333 233.401n 0 234.0n 0 234.001n 0.72 234.4n 0.72 234.401n 0 235.0n 0 235.001n 0.7666666666666666 235.4n 0.7666666666666666 235.401n 0 236.0n 0 236.001n 0.8133333333333332 236.4n 0.8133333333333332 236.401n 0 237.0n 0 237.001n 0.8599999999999999 237.4n 0.8599999999999999 237.401n 0 238.0n 0 238.001n 0.9066666666666667 238.4n 0.9066666666666667 238.401n 0 239.0n 0 239.001n 0.9533333333333331 239.4n 0.9533333333333331 239.401n 0 240.0n 0 240.001n 1.0 240.4n 1.0 240.401n 0 ]
Vwl16 (WL16 0) vsource type=pwl wave=[0 0 241.0n 0 241.001n 0.3 241.4n 0.3 241.401n 0 242.0n 0 242.001n 0.3466666666666667 242.4n 0.3466666666666667 242.401n 0 243.0n 0 243.001n 0.3933333333333333 243.4n 0.3933333333333333 243.401n 0 244.0n 0 244.001n 0.43999999999999995 244.4n 0.43999999999999995 244.401n 0 245.0n 0 245.001n 0.48666666666666664 245.4n 0.48666666666666664 245.401n 0 246.0n 0 246.001n 0.5333333333333333 246.4n 0.5333333333333333 246.401n 0 247.0n 0 247.001n 0.58 247.4n 0.58 247.401n 0 248.0n 0 248.001n 0.6266666666666666 248.4n 0.6266666666666666 248.401n 0 249.0n 0 249.001n 0.6733333333333333 249.4n 0.6733333333333333 249.401n 0 250.0n 0 250.001n 0.72 250.4n 0.72 250.401n 0 251.0n 0 251.001n 0.7666666666666666 251.4n 0.7666666666666666 251.401n 0 252.0n 0 252.001n 0.8133333333333332 252.4n 0.8133333333333332 252.401n 0 253.0n 0 253.001n 0.8599999999999999 253.4n 0.8599999999999999 253.401n 0 254.0n 0 254.001n 0.9066666666666667 254.4n 0.9066666666666667 254.401n 0 255.0n 0 255.001n 0.9533333333333331 255.4n 0.9533333333333331 255.401n 0 256.0n 0 256.001n 1.0 256.4n 1.0 256.401n 0 ]
Vwl17 (WL17 0) vsource dc=1
Vwl18 (WL18 0) vsource dc=1
Vwl19 (WL19 0) vsource dc=1
Vwl20 (WL20 0) vsource dc=1
Vwl21 (WL21 0) vsource dc=1
Vwl22 (WL22 0) vsource dc=1
Vwl23 (WL23 0) vsource dc=1
Vwl24 (WL24 0) vsource dc=1
Vwl25 (WL25 0) vsource dc=1

// en_share Signal
Ven_sharing (en_sharing 0) vsource type=pwl wave=[0 0 1.4n 0 1.401n 1.2 1.6n 1.2 1.601n 0 2.4n 0 2.401n 1.2 2.6n 1.2 2.601n 0 3.4n 0 3.401n 1.2 3.6n 1.2 3.601n 0 4.4n 0 4.401n 1.2 4.6n 1.2 4.601n 0 5.4n 0 5.401n 1.2 5.6n 1.2 5.601n 0 6.4n 0 6.401n 1.2 6.6n 1.2 6.601n 0 7.4n 0 7.401n 1.2 7.6n 1.2 7.601n 0 8.4n 0 8.401n 1.2 8.6n 1.2 8.601n 0 9.4n 0 9.401n 1.2 9.6n 1.2 9.601n 0 10.4n 0 10.401n 1.2 10.6n 1.2 10.601n 0 11.4n 0 11.401n 1.2 11.6n 1.2 11.601n 0 12.4n 0 12.401n 1.2 12.6n 1.2 12.601n 0 13.4n 0 13.401n 1.2 13.6n 1.2 13.601n 0 14.4n 0 14.401n 1.2 14.6n 1.2 14.601n 0 15.4n 0 15.401n 1.2 15.6n 1.2 15.601n 0 16.4n 0 16.401n 1.2 16.6n 1.2 16.601n 0 17.4n 0 17.401n 1.2 17.6n 1.2 17.601n 0 18.4n 0 18.401n 1.2 18.6n 1.2 18.601n 0 19.4n 0 19.401n 1.2 19.6n 1.2 19.601n 0 20.4n 0 20.401n 1.2 20.6n 1.2 20.601n 0 21.4n 0 21.401n 1.2 21.6n 1.2 21.601n 0 22.4n 0 22.401n 1.2 22.6n 1.2 22.601n 0 23.4n 0 23.401n 1.2 23.6n 1.2 23.601n 0 24.4n 0 24.401n 1.2 24.6n 1.2 24.601n 0 25.4n 0 25.401n 1.2 25.6n 1.2 25.601n 0 26.4n 0 26.401n 1.2 26.6n 1.2 26.601n 0 27.4n 0 27.401n 1.2 27.6n 1.2 27.601n 0 28.4n 0 28.401n 1.2 28.6n 1.2 28.601n 0 29.4n 0 29.401n 1.2 29.6n 1.2 29.601n 0 30.4n 0 30.401n 1.2 30.6n 1.2 30.601n 0 31.4n 0 31.401n 1.2 31.6n 1.2 31.601n 0 32.4n 0 32.401n 1.2 32.6n 1.2 32.601n 0 33.4n 0 33.401n 1.2 33.6n 1.2 33.601n 0 34.4n 0 34.401n 1.2 34.6n 1.2 34.601n 0 35.4n 0 35.401n 1.2 35.6n 1.2 35.601n 0 36.4n 0 36.401n 1.2 36.6n 1.2 36.601n 0 37.4n 0 37.401n 1.2 37.6n 1.2 37.601n 0 38.4n 0 38.401n 1.2 38.6n 1.2 38.601n 0 39.4n 0 39.401n 1.2 39.6n 1.2 39.601n 0 40.4n 0 40.401n 1.2 40.6n 1.2 40.601n 0 41.4n 0 41.401n 1.2 41.6n 1.2 41.601n 0 42.4n 0 42.401n 1.2 42.6n 1.2 42.601n 0 43.4n 0 43.401n 1.2 43.6n 1.2 43.601n 0 44.4n 0 44.401n 1.2 44.6n 1.2 44.601n 0 45.4n 0 45.401n 1.2 45.6n 1.2 45.601n 0 46.4n 0 46.401n 1.2 46.6n 1.2 46.601n 0 47.4n 0 47.401n 1.2 47.6n 1.2 47.601n 0 48.4n 0 48.401n 1.2 48.6n 1.2 48.601n 0 49.4n 0 49.401n 1.2 49.6n 1.2 49.601n 0 50.4n 0 50.401n 1.2 50.6n 1.2 50.601n 0 51.4n 0 51.401n 1.2 51.6n 1.2 51.601n 0 52.4n 0 52.401n 1.2 52.6n 1.2 52.601n 0 53.4n 0 53.401n 1.2 53.6n 1.2 53.601n 0 54.4n 0 54.401n 1.2 54.6n 1.2 54.601n 0 55.4n 0 55.401n 1.2 55.6n 1.2 55.601n 0 56.4n 0 56.401n 1.2 56.6n 1.2 56.601n 0 57.4n 0 57.401n 1.2 57.6n 1.2 57.601n 0 58.4n 0 58.401n 1.2 58.6n 1.2 58.601n 0 59.4n 0 59.401n 1.2 59.6n 1.2 59.601n 0 60.4n 0 60.401n 1.2 60.6n 1.2 60.601n 0 61.4n 0 61.401n 1.2 61.6n 1.2 61.601n 0 62.4n 0 62.401n 1.2 62.6n 1.2 62.601n 0 63.4n 0 63.401n 1.2 63.6n 1.2 63.601n 0 64.4n 0 64.401n 1.2 64.6n 1.2 64.601n 0 65.4n 0 65.401n 1.2 65.6n 1.2 65.601n 0 66.4n 0 66.401n 1.2 66.6n 1.2 66.601n 0 67.4n 0 67.401n 1.2 67.6n 1.2 67.601n 0 68.4n 0 68.401n 1.2 68.6n 1.2 68.601n 0 69.4n 0 69.401n 1.2 69.6n 1.2 69.601n 0 70.4n 0 70.401n 1.2 70.6n 1.2 70.601n 0 71.4n 0 71.401n 1.2 71.6n 1.2 71.601n 0 72.4n 0 72.401n 1.2 72.6n 1.2 72.601n 0 73.4n 0 73.401n 1.2 73.6n 1.2 73.601n 0 74.4n 0 74.401n 1.2 74.6n 1.2 74.601n 0 75.4n 0 75.401n 1.2 75.6n 1.2 75.601n 0 76.4n 0 76.401n 1.2 76.6n 1.2 76.601n 0 77.4n 0 77.401n 1.2 77.6n 1.2 77.601n 0 78.4n 0 78.401n 1.2 78.6n 1.2 78.601n 0 79.4n 0 79.401n 1.2 79.6n 1.2 79.601n 0 80.4n 0 80.401n 1.2 80.6n 1.2 80.601n 0 81.4n 0 81.401n 1.2 81.6n 1.2 81.601n 0 82.4n 0 82.401n 1.2 82.6n 1.2 82.601n 0 83.4n 0 83.401n 1.2 83.6n 1.2 83.601n 0 84.4n 0 84.401n 1.2 84.6n 1.2 84.601n 0 85.4n 0 85.401n 1.2 85.6n 1.2 85.601n 0 86.4n 0 86.401n 1.2 86.6n 1.2 86.601n 0 87.4n 0 87.401n 1.2 87.6n 1.2 87.601n 0 88.4n 0 88.401n 1.2 88.6n 1.2 88.601n 0 89.4n 0 89.401n 1.2 89.6n 1.2 89.601n 0 90.4n 0 90.401n 1.2 90.6n 1.2 90.601n 0 91.4n 0 91.401n 1.2 91.6n 1.2 91.601n 0 92.4n 0 92.401n 1.2 92.6n 1.2 92.601n 0 93.4n 0 93.401n 1.2 93.6n 1.2 93.601n 0 94.4n 0 94.401n 1.2 94.6n 1.2 94.601n 0 95.4n 0 95.401n 1.2 95.6n 1.2 95.601n 0 96.4n 0 96.401n 1.2 96.6n 1.2 96.601n 0 97.4n 0 97.401n 1.2 97.6n 1.2 97.601n 0 98.4n 0 98.401n 1.2 98.6n 1.2 98.601n 0 99.4n 0 99.401n 1.2 99.6n 1.2 99.601n 0 100.4n 0 100.401n 1.2 100.6n 1.2 100.601n 0 101.4n 0 101.401n 1.2 101.6n 1.2 101.601n 0 102.4n 0 102.401n 1.2 102.6n 1.2 102.601n 0 103.4n 0 103.401n 1.2 103.6n 1.2 103.601n 0 104.4n 0 104.401n 1.2 104.6n 1.2 104.601n 0 105.4n 0 105.401n 1.2 105.6n 1.2 105.601n 0 106.4n 0 106.401n 1.2 106.6n 1.2 106.601n 0 107.4n 0 107.401n 1.2 107.6n 1.2 107.601n 0 108.4n 0 108.401n 1.2 108.6n 1.2 108.601n 0 109.4n 0 109.401n 1.2 109.6n 1.2 109.601n 0 110.4n 0 110.401n 1.2 110.6n 1.2 110.601n 0 111.4n 0 111.401n 1.2 111.6n 1.2 111.601n 0 112.4n 0 112.401n 1.2 112.6n 1.2 112.601n 0 113.4n 0 113.401n 1.2 113.6n 1.2 113.601n 0 114.4n 0 114.401n 1.2 114.6n 1.2 114.601n 0 115.4n 0 115.401n 1.2 115.6n 1.2 115.601n 0 116.4n 0 116.401n 1.2 116.6n 1.2 116.601n 0 117.4n 0 117.401n 1.2 117.6n 1.2 117.601n 0 118.4n 0 118.401n 1.2 118.6n 1.2 118.601n 0 119.4n 0 119.401n 1.2 119.6n 1.2 119.601n 0 120.4n 0 120.401n 1.2 120.6n 1.2 120.601n 0 121.4n 0 121.401n 1.2 121.6n 1.2 121.601n 0 122.4n 0 122.401n 1.2 122.6n 1.2 122.601n 0 123.4n 0 123.401n 1.2 123.6n 1.2 123.601n 0 124.4n 0 124.401n 1.2 124.6n 1.2 124.601n 0 125.4n 0 125.401n 1.2 125.6n 1.2 125.601n 0 126.4n 0 126.401n 1.2 126.6n 1.2 126.601n 0 127.4n 0 127.401n 1.2 127.6n 1.2 127.601n 0 128.4n 0 128.401n 1.2 128.6n 1.2 128.601n 0 129.4n 0 129.401n 1.2 129.6n 1.2 129.601n 0 130.4n 0 130.401n 1.2 130.6n 1.2 130.601n 0 131.4n 0 131.401n 1.2 131.6n 1.2 131.601n 0 132.4n 0 132.401n 1.2 132.6n 1.2 132.601n 0 133.4n 0 133.401n 1.2 133.6n 1.2 133.601n 0 134.4n 0 134.401n 1.2 134.6n 1.2 134.601n 0 135.4n 0 135.401n 1.2 135.6n 1.2 135.601n 0 136.4n 0 136.401n 1.2 136.6n 1.2 136.601n 0 137.4n 0 137.401n 1.2 137.6n 1.2 137.601n 0 138.4n 0 138.401n 1.2 138.6n 1.2 138.601n 0 139.4n 0 139.401n 1.2 139.6n 1.2 139.601n 0 140.4n 0 140.401n 1.2 140.6n 1.2 140.601n 0 141.4n 0 141.401n 1.2 141.6n 1.2 141.601n 0 142.4n 0 142.401n 1.2 142.6n 1.2 142.601n 0 143.4n 0 143.401n 1.2 143.6n 1.2 143.601n 0 144.4n 0 144.401n 1.2 144.6n 1.2 144.601n 0 145.4n 0 145.401n 1.2 145.6n 1.2 145.601n 0 146.4n 0 146.401n 1.2 146.6n 1.2 146.601n 0 147.4n 0 147.401n 1.2 147.6n 1.2 147.601n 0 148.4n 0 148.401n 1.2 148.6n 1.2 148.601n 0 149.4n 0 149.401n 1.2 149.6n 1.2 149.601n 0 150.4n 0 150.401n 1.2 150.6n 1.2 150.601n 0 151.4n 0 151.401n 1.2 151.6n 1.2 151.601n 0 152.4n 0 152.401n 1.2 152.6n 1.2 152.601n 0 153.4n 0 153.401n 1.2 153.6n 1.2 153.601n 0 154.4n 0 154.401n 1.2 154.6n 1.2 154.601n 0 155.4n 0 155.401n 1.2 155.6n 1.2 155.601n 0 156.4n 0 156.401n 1.2 156.6n 1.2 156.601n 0 157.4n 0 157.401n 1.2 157.6n 1.2 157.601n 0 158.4n 0 158.401n 1.2 158.6n 1.2 158.601n 0 159.4n 0 159.401n 1.2 159.6n 1.2 159.601n 0 160.4n 0 160.401n 1.2 160.6n 1.2 160.601n 0 161.4n 0 161.401n 1.2 161.6n 1.2 161.601n 0 162.4n 0 162.401n 1.2 162.6n 1.2 162.601n 0 163.4n 0 163.401n 1.2 163.6n 1.2 163.601n 0 164.4n 0 164.401n 1.2 164.6n 1.2 164.601n 0 165.4n 0 165.401n 1.2 165.6n 1.2 165.601n 0 166.4n 0 166.401n 1.2 166.6n 1.2 166.601n 0 167.4n 0 167.401n 1.2 167.6n 1.2 167.601n 0 168.4n 0 168.401n 1.2 168.6n 1.2 168.601n 0 169.4n 0 169.401n 1.2 169.6n 1.2 169.601n 0 170.4n 0 170.401n 1.2 170.6n 1.2 170.601n 0 171.4n 0 171.401n 1.2 171.6n 1.2 171.601n 0 172.4n 0 172.401n 1.2 172.6n 1.2 172.601n 0 173.4n 0 173.401n 1.2 173.6n 1.2 173.601n 0 174.4n 0 174.401n 1.2 174.6n 1.2 174.601n 0 175.4n 0 175.401n 1.2 175.6n 1.2 175.601n 0 176.4n 0 176.401n 1.2 176.6n 1.2 176.601n 0 177.4n 0 177.401n 1.2 177.6n 1.2 177.601n 0 178.4n 0 178.401n 1.2 178.6n 1.2 178.601n 0 179.4n 0 179.401n 1.2 179.6n 1.2 179.601n 0 180.4n 0 180.401n 1.2 180.6n 1.2 180.601n 0 181.4n 0 181.401n 1.2 181.6n 1.2 181.601n 0 182.4n 0 182.401n 1.2 182.6n 1.2 182.601n 0 183.4n 0 183.401n 1.2 183.6n 1.2 183.601n 0 184.4n 0 184.401n 1.2 184.6n 1.2 184.601n 0 185.4n 0 185.401n 1.2 185.6n 1.2 185.601n 0 186.4n 0 186.401n 1.2 186.6n 1.2 186.601n 0 187.4n 0 187.401n 1.2 187.6n 1.2 187.601n 0 188.4n 0 188.401n 1.2 188.6n 1.2 188.601n 0 189.4n 0 189.401n 1.2 189.6n 1.2 189.601n 0 190.4n 0 190.401n 1.2 190.6n 1.2 190.601n 0 191.4n 0 191.401n 1.2 191.6n 1.2 191.601n 0 192.4n 0 192.401n 1.2 192.6n 1.2 192.601n 0 193.4n 0 193.401n 1.2 193.6n 1.2 193.601n 0 194.4n 0 194.401n 1.2 194.6n 1.2 194.601n 0 195.4n 0 195.401n 1.2 195.6n 1.2 195.601n 0 196.4n 0 196.401n 1.2 196.6n 1.2 196.601n 0 197.4n 0 197.401n 1.2 197.6n 1.2 197.601n 0 198.4n 0 198.401n 1.2 198.6n 1.2 198.601n 0 199.4n 0 199.401n 1.2 199.6n 1.2 199.601n 0 200.4n 0 200.401n 1.2 200.6n 1.2 200.601n 0 201.4n 0 201.401n 1.2 201.6n 1.2 201.601n 0 202.4n 0 202.401n 1.2 202.6n 1.2 202.601n 0 203.4n 0 203.401n 1.2 203.6n 1.2 203.601n 0 204.4n 0 204.401n 1.2 204.6n 1.2 204.601n 0 205.4n 0 205.401n 1.2 205.6n 1.2 205.601n 0 206.4n 0 206.401n 1.2 206.6n 1.2 206.601n 0 207.4n 0 207.401n 1.2 207.6n 1.2 207.601n 0 208.4n 0 208.401n 1.2 208.6n 1.2 208.601n 0 209.4n 0 209.401n 1.2 209.6n 1.2 209.601n 0 210.4n 0 210.401n 1.2 210.6n 1.2 210.601n 0 211.4n 0 211.401n 1.2 211.6n 1.2 211.601n 0 212.4n 0 212.401n 1.2 212.6n 1.2 212.601n 0 213.4n 0 213.401n 1.2 213.6n 1.2 213.601n 0 214.4n 0 214.401n 1.2 214.6n 1.2 214.601n 0 215.4n 0 215.401n 1.2 215.6n 1.2 215.601n 0 216.4n 0 216.401n 1.2 216.6n 1.2 216.601n 0 217.4n 0 217.401n 1.2 217.6n 1.2 217.601n 0 218.4n 0 218.401n 1.2 218.6n 1.2 218.601n 0 219.4n 0 219.401n 1.2 219.6n 1.2 219.601n 0 220.4n 0 220.401n 1.2 220.6n 1.2 220.601n 0 221.4n 0 221.401n 1.2 221.6n 1.2 221.601n 0 222.4n 0 222.401n 1.2 222.6n 1.2 222.601n 0 223.4n 0 223.401n 1.2 223.6n 1.2 223.601n 0 224.4n 0 224.401n 1.2 224.6n 1.2 224.601n 0 225.4n 0 225.401n 1.2 225.6n 1.2 225.601n 0 226.4n 0 226.401n 1.2 226.6n 1.2 226.601n 0 227.4n 0 227.401n 1.2 227.6n 1.2 227.601n 0 228.4n 0 228.401n 1.2 228.6n 1.2 228.601n 0 229.4n 0 229.401n 1.2 229.6n 1.2 229.601n 0 230.4n 0 230.401n 1.2 230.6n 1.2 230.601n 0 231.4n 0 231.401n 1.2 231.6n 1.2 231.601n 0 232.4n 0 232.401n 1.2 232.6n 1.2 232.601n 0 233.4n 0 233.401n 1.2 233.6n 1.2 233.601n 0 234.4n 0 234.401n 1.2 234.6n 1.2 234.601n 0 235.4n 0 235.401n 1.2 235.6n 1.2 235.601n 0 236.4n 0 236.401n 1.2 236.6n 1.2 236.601n 0 237.4n 0 237.401n 1.2 237.6n 1.2 237.601n 0 238.4n 0 238.401n 1.2 238.6n 1.2 238.601n 0 239.4n 0 239.401n 1.2 239.6n 1.2 239.601n 0 240.4n 0 240.401n 1.2 240.6n 1.2 240.601n 0 241.4n 0 241.401n 1.2 241.6n 1.2 241.601n 0 242.4n 0 242.401n 1.2 242.6n 1.2 242.601n 0 243.4n 0 243.401n 1.2 243.6n 1.2 243.601n 0 244.4n 0 244.401n 1.2 244.6n 1.2 244.601n 0 245.4n 0 245.401n 1.2 245.6n 1.2 245.601n 0 246.4n 0 246.401n 1.2 246.6n 1.2 246.601n 0 247.4n 0 247.401n 1.2 247.6n 1.2 247.601n 0 248.4n 0 248.401n 1.2 248.6n 1.2 248.601n 0 249.4n 0 249.401n 1.2 249.6n 1.2 249.601n 0 250.4n 0 250.401n 1.2 250.6n 1.2 250.601n 0 251.4n 0 251.401n 1.2 251.6n 1.2 251.601n 0 252.4n 0 252.401n 1.2 252.6n 1.2 252.601n 0 253.4n 0 253.401n 1.2 253.6n 1.2 253.601n 0 254.4n 0 254.401n 1.2 254.6n 1.2 254.601n 0 255.4n 0 255.401n 1.2 255.6n 1.2 255.601n 0 256.4n 0 256.401n 1.2 256.6n 1.2 256.601n 0 ]

// en_sample Signal
 Vensample (ensample 0) vsource dc=1.2

// en_acc Signal
 Venacc (enacc 0) vsource dc=1.2

// en_sample Signal
Vvss_adc (vss_adc 0) vsource dc=0.050
Vvdd_adc (vdd_adc 0) vsource dc=0.450
Vadc_en (ADC_en 0) vsource dc=0
Vreset_shiftreg (Reset_ShiftReg 0) vsource dc=0
Vreset (Reset 0) vsource dc=0
Vclk_ShiftReg (clk_ShiftReg 0) vsource dc=0
Vclk_logic (clk_logic 0) vsource dc=0
Vclk_SA (clk_SA 0) vsource dc=0
VOutput_valid (Output_valid 0) vsource dc=0

simulatorOptions options temp=27
mc montecarlo saveprocessparams=yes variations=all donominal=yes savefamilyplots=yes appendsd=yes scalarfile="output_energy.txt" numruns=1000 {
    tran tran start=0 stop=257n
    export product_val = oceanEval( "value(getData(\"product\" ?result \"tran\") 1.59e-09 ?xName \"time\") ")
}

//save product

ic d3=1 d2=1 d1=1 d0=1 D3=0 D2=0 D1=0 D0=0 Vx=450m sample=0 accumulation=0 I_1_1.qb=1.0 I_1_1.q=0.0 I_1_2.qb=1.0 I_1_2.q=0.0 I_1_3.qb=1.0 I_1_3.q=0.0 I_1_4.qb=1.0 I_1_4.q=0.0 I_2_1.qb=1.0 I_2_1.q=0.0 I_2_2.qb=1.0 I_2_2.q=0.0 I_2_3.qb=1.0 I_2_3.q=0.0 I_2_4.qb=0.0 I_2_4.q=1.0 I_3_1.qb=1.0 I_3_1.q=0.0 I_3_2.qb=1.0 I_3_2.q=0.0 I_3_3.qb=0.0 I_3_3.q=1.0 I_3_4.qb=1.0 I_3_4.q=0.0 I_4_1.qb=1.0 I_4_1.q=0.0 I_4_2.qb=1.0 I_4_2.q=0.0 I_4_3.qb=0.0 I_4_3.q=1.0 I_4_4.qb=0.0 I_4_4.q=1.0 I_5_1.qb=1.0 I_5_1.q=0.0 I_5_2.qb=0.0 I_5_2.q=1.0 I_5_3.qb=1.0 I_5_3.q=0.0 I_5_4.qb=1.0 I_5_4.q=0.0 I_6_1.qb=1.0 I_6_1.q=0.0 I_6_2.qb=0.0 I_6_2.q=1.0 I_6_3.qb=1.0 I_6_3.q=0.0 I_6_4.qb=0.0 I_6_4.q=1.0 I_7_1.qb=1.0 I_7_1.q=0.0 I_7_2.qb=0.0 I_7_2.q=1.0 I_7_3.qb=0.0 I_7_3.q=1.0 I_7_4.qb=1.0 I_7_4.q=0.0 I_8_1.qb=1.0 I_8_1.q=0.0 I_8_2.qb=0.0 I_8_2.q=1.0 I_8_3.qb=0.0 I_8_3.q=1.0 I_8_4.qb=0.0 I_8_4.q=1.0 I_9_1.qb=1.0 I_9_1.q=0.0 I_9_2.qb=1.0 I_9_2.q=0.0 I_9_3.qb=1.0 I_9_3.q=0.0 I_9_4.qb=1.0 I_9_4.q=0.0 I_10_1.qb=1.0 I_10_1.q=0.0 I_10_2.qb=1.0 I_10_2.q=0.0 I_10_3.qb=1.0 I_10_3.q=0.0 I_10_4.qb=1.0 I_10_4.q=0.0 I_11_1.qb=1.0 I_11_1.q=0.0 I_11_2.qb=1.0 I_11_2.q=0.0 I_11_3.qb=1.0 I_11_3.q=0.0 I_11_4.qb=1.0 I_11_4.q=0.0 I_12_1.qb=1.0 I_12_1.q=0.0 I_12_2.qb=1.0 I_12_2.q=0.0 I_12_3.qb=1.0 I_12_3.q=0.0 I_12_4.qb=1.0 I_12_4.q=0.0 I_13_1.qb=1.0 I_13_1.q=0.0 I_13_2.qb=1.0 I_13_2.q=0.0 I_13_3.qb=1.0 I_13_3.q=0.0 I_13_4.qb=1.0 I_13_4.q=0.0 I_14_1.qb=1.0 I_14_1.q=0.0 I_14_2.qb=1.0 I_14_2.q=0.0 I_14_3.qb=1.0 I_14_3.q=0.0 I_14_4.qb=1.0 I_14_4.q=0.0 I_15_1.qb=1.0 I_15_1.q=0.0 I_15_2.qb=1.0 I_15_2.q=0.0 I_15_3.qb=1.0 I_15_3.q=0.0 I_15_4.qb=1.0 I_15_4.q=0.0 I_16_1.qb=1.0 I_16_1.q=0.0 I_16_2.qb=1.0 I_16_2.q=0.0 I_16_3.qb=1.0 I_16_3.q=0.0 I_16_4.qb=1.0 I_16_4.q=0.0
